** sch_path: /foss/designs/libs/switch_matrix_gf180mcu_9t5v0/full_switch_matrix_130_by_25/full_switch_matrix_130_by_25_no_probes.sch

./include /foss/pdks/gf180mcuD/libs.ref/gf180mcu_fd_sc_mcu9t5v0/spice/gf180mcu_fd_sc_mcu9t5v0.spice

.subckt full_switch_matrix_130_by_25_no_probes data clock enable D_out PIN[1] PIN[2] PIN[3] PIN[4] PIN[5] PIN[6] PIN[7] PIN[8]
+ PIN[9] PIN[10] PIN[11] PIN[12] PIN[13] PIN[14] PIN[15] PIN[16] PIN[17] PIN[18] PIN[19] PIN[20] PIN[21] PIN[22] PIN[23] PIN[24] PIN[25]
+ PIN[26] PIN[27] PIN[28] PIN[29] PIN[30] PIN[31] PIN[32] PIN[33] PIN[34] PIN[35] PIN[36] PIN[37] PIN[38] PIN[39] PIN[40] PIN[41] PIN[42]
+ PIN[43] PIN[44] PIN[45] PIN[46] PIN[47] PIN[48] PIN[49] PIN[50] PIN[51] PIN[52] PIN[53] PIN[54] PIN[55] PIN[56] PIN[57] PIN[58] PIN[59]
+ PIN[60] PIN[61] PIN[62] PIN[63] PIN[64] PIN[65] PIN[66] PIN[67] PIN[68] PIN[69] PIN[70] PIN[71] PIN[72] PIN[73] PIN[74] PIN[75] PIN[76]
+ PIN[77] PIN[78] PIN[79] PIN[80] PIN[81] PIN[82] PIN[83] PIN[84] PIN[85] PIN[86] PIN[87] PIN[88] PIN[89] PIN[90] PIN[91] PIN[92] PIN[93]
+ PIN[94] PIN[95] PIN[96] PIN[97] PIN[98] PIN[99] PIN[100] PIN[101] PIN[102] PIN[103] PIN[104] PIN[105] PIN[106] PIN[107] PIN[108] PIN[109]
+ PIN[110] PIN[111] PIN[112] PIN[113] PIN[114] PIN[115] PIN[116] PIN[117] PIN[118] PIN[119] PIN[120] PIN[121] PIN[122] PIN[123] PIN[124]
+ PIN[125] PIN[126] PIN[127] PIN[128] PIN[129] PIN[130] BUS[1] BUS[2] BUS[3] BUS[4] BUS[5] BUS[6] BUS[7] BUS[8] BUS[9] BUS[10] BUS[11]
+ BUS[12] BUS[13] BUS[14] BUS[15] BUS[16] BUS[17] BUS[18] BUS[19] BUS[20] BUS[21] BUS[22] BUS[23] BUS[24] BUS[25] VSSd VDDd
*.PININFO data:I clock:I enable:I D_out:O PIN[1:130]:O BUS[1:25]:O VSSd:B VDDd:B
xSWMATRIX data_in D_out1 PHI_1_in PHI_2_in BUS[1] BUS[2] BUS[3] BUS[4] BUS[5] BUS[6] BUS[7] BUS[8] BUS[9] BUS[10] BUS[11] BUS[12]
+ BUS[13] BUS[14] BUS[15] BUS[16] BUS[17] BUS[18] BUS[19] BUS[20] BUS[21] BUS[22] BUS[23] BUS[24] BUS[25] PIN[1] PIN[2] PIN[3] PIN[4]
+ PIN[5] PIN[6] PIN[7] PIN[8] PIN[9] PIN[10] PIN[11] PIN[12] PIN[13] PIN[14] PIN[15] PIN[16] PIN[17] PIN[18] PIN[19] PIN[20] PIN[21]
+ PIN[22] PIN[23] PIN[24] PIN[25] PIN[26] PIN[27] PIN[28] PIN[29] PIN[30] PIN[31] PIN[32] PIN[33] PIN[34] PIN[35] PIN[36] PIN[37] PIN[38]
+ PIN[39] PIN[40] PIN[41] PIN[42] PIN[43] PIN[44] PIN[45] PIN[46] PIN[47] PIN[48] PIN[49] PIN[50] PIN[51] PIN[52] PIN[53] PIN[54] PIN[55]
+ PIN[56] PIN[57] PIN[58] PIN[59] PIN[60] PIN[61] PIN[62] VDDd VSSd enable_in Q_out[1] Q_out[2] Q_out[3] Q_out[4] Q_out[5] Q_out[6]
+ Q_out[7] Q_out[8] Q_out[9] Q_out[10] Q_out[11] Q_out[12] Q_out[13] Q_out[14] Q_out[15] Q_out[16] Q_out[17] Q_out[18] Q_out[19] Q_out[20]
+ Q_out[21] Q_out[22] Q_out[23] Q_out[24] Q_out[25] Q_out[26] Q_out[27] Q_out[28] Q_out[29] Q_out[30] Q_out[31] Q_out[32] Q_out[33] Q_out[34]
+ Q_out[35] Q_out[36] Q_out[37] Q_out[38] Q_out[39] Q_out[40] Q_out[41] Q_out[42] Q_out[43] Q_out[44] Q_out[45] Q_out[46] Q_out[47] Q_out[48]
+ Q_out[49] Q_out[50] Q_out[51] Q_out[52] Q_out[53] Q_out[54] Q_out[55] Q_out[56] Q_out[57] Q_out[58] Q_out[59] Q_out[60] Q_out[61] Q_out[62]
+ Q_out[63] Q_out[64] Q_out[65] Q_out[66] Q_out[67] Q_out[68] Q_out[69] Q_out[70] Q_out[71] Q_out[72] Q_out[73] Q_out[74] Q_out[75] Q_out[76]
+ Q_out[77] Q_out[78] Q_out[79] Q_out[80] Q_out[81] Q_out[82] Q_out[83] Q_out[84] Q_out[85] Q_out[86] Q_out[87] Q_out[88] Q_out[89] Q_out[90]
+ Q_out[91] Q_out[92] Q_out[93] Q_out[94] Q_out[95] Q_out[96] Q_out[97] Q_out[98] Q_out[99] Q_out[100] Q_out[101] Q_out[102] Q_out[103]
+ Q_out[104] Q_out[105] Q_out[106] Q_out[107] Q_out[108] Q_out[109] Q_out[110] Q_out[111] Q_out[112] Q_out[113] Q_out[114] Q_out[115]
+ Q_out[116] Q_out[117] Q_out[118] Q_out[119] Q_out[120] Q_out[121] Q_out[122] Q_out[123] Q_out[124] Q_out[125] Q_out[126] Q_out[127]
+ Q_out[128] Q_out[129] Q_out[130] Q_out[131] Q_out[132] Q_out[133] Q_out[134] Q_out[135] Q_out[136] Q_out[137] Q_out[138] Q_out[139]
+ Q_out[140] Q_out[141] Q_out[142] Q_out[143] Q_out[144] Q_out[145] Q_out[146] Q_out[147] Q_out[148] Q_out[149] Q_out[150] Q_out[151]
+ Q_out[152] Q_out[153] Q_out[154] Q_out[155] Q_out[156] Q_out[157] Q_out[158] Q_out[159] Q_out[160] Q_out[161] Q_out[162] Q_out[163]
+ Q_out[164] Q_out[165] Q_out[166] Q_out[167] Q_out[168] Q_out[169] Q_out[170] Q_out[171] Q_out[172] Q_out[173] Q_out[174] Q_out[175]
+ Q_out[176] Q_out[177] Q_out[178] Q_out[179] Q_out[180] Q_out[181] Q_out[182] Q_out[183] Q_out[184] Q_out[185] Q_out[186] Q_out[187]
+ Q_out[188] Q_out[189] Q_out[190] Q_out[191] Q_out[192] Q_out[193] Q_out[194] Q_out[195] Q_out[196] Q_out[197] Q_out[198] Q_out[199]
+ Q_out[200] Q_out[201] Q_out[202] Q_out[203] Q_out[204] Q_out[205] Q_out[206] Q_out[207] Q_out[208] Q_out[209] Q_out[210] Q_out[211]
+ Q_out[212] Q_out[213] Q_out[214] Q_out[215] Q_out[216] Q_out[217] Q_out[218] Q_out[219] Q_out[220] Q_out[221] Q_out[222] Q_out[223]
+ Q_out[224] Q_out[225] Q_out[226] Q_out[227] Q_out[228] Q_out[229] Q_out[230] Q_out[231] Q_out[232] Q_out[233] Q_out[234] Q_out[235]
+ Q_out[236] Q_out[237] Q_out[238] Q_out[239] Q_out[240] Q_out[241] Q_out[242] Q_out[243] Q_out[244] Q_out[245] Q_out[246] Q_out[247]
+ Q_out[248] Q_out[249] Q_out[250] Q_out[251] Q_out[252] Q_out[253] Q_out[254] Q_out[255] Q_out[256] Q_out[257] Q_out[258] Q_out[259]
+ Q_out[260] Q_out[261] Q_out[262] Q_out[263] Q_out[264] Q_out[265] Q_out[266] Q_out[267] Q_out[268] Q_out[269] Q_out[270] Q_out[271]
+ Q_out[272] Q_out[273] Q_out[274] Q_out[275] Q_out[276] Q_out[277] Q_out[278] Q_out[279] Q_out[280] Q_out[281] Q_out[282] Q_out[283]
+ Q_out[284] Q_out[285] Q_out[286] Q_out[287] Q_out[288] Q_out[289] Q_out[290] Q_out[291] Q_out[292] Q_out[293] Q_out[294] Q_out[295]
+ Q_out[296] Q_out[297] Q_out[298] Q_out[299] Q_out[300] Q_out[301] Q_out[302] Q_out[303] Q_out[304] Q_out[305] Q_out[306] Q_out[307]
+ Q_out[308] Q_out[309] Q_out[310] Q_out[311] Q_out[312] Q_out[313] Q_out[314] Q_out[315] Q_out[316] Q_out[317] Q_out[318] Q_out[319]
+ Q_out[320] Q_out[321] Q_out[322] Q_out[323] Q_out[324] Q_out[325] Q_out[326] Q_out[327] Q_out[328] Q_out[329] Q_out[330] Q_out[331]
+ Q_out[332] Q_out[333] Q_out[334] Q_out[335] Q_out[336] Q_out[337] Q_out[338] Q_out[339] Q_out[340] Q_out[341] Q_out[342] Q_out[343]
+ Q_out[344] Q_out[345] Q_out[346] Q_out[347] Q_out[348] Q_out[349] Q_out[350] Q_out[351] Q_out[352] Q_out[353] Q_out[354] Q_out[355]
+ Q_out[356] Q_out[357] Q_out[358] Q_out[359] Q_out[360] Q_out[361] Q_out[362] Q_out[363] Q_out[364] Q_out[365] Q_out[366] Q_out[367]
+ Q_out[368] Q_out[369] Q_out[370] Q_out[371] Q_out[372] Q_out[373] Q_out[374] Q_out[375] Q_out[376] Q_out[377] Q_out[378] Q_out[379]
+ Q_out[380] Q_out[381] Q_out[382] Q_out[383] Q_out[384] Q_out[385] Q_out[386] Q_out[387] Q_out[388] Q_out[389] Q_out[390] Q_out[391]
+ Q_out[392] Q_out[393] Q_out[394] Q_out[395] Q_out[396] Q_out[397] Q_out[398] Q_out[399] Q_out[400] Q_out[401] Q_out[402] Q_out[403]
+ Q_out[404] Q_out[405] Q_out[406] Q_out[407] Q_out[408] Q_out[409] Q_out[410] Q_out[411] Q_out[412] Q_out[413] Q_out[414] Q_out[415]
+ Q_out[416] Q_out[417] Q_out[418] Q_out[419] Q_out[420] Q_out[421] Q_out[422] Q_out[423] Q_out[424] Q_out[425] Q_out[426] Q_out[427]
+ Q_out[428] Q_out[429] Q_out[430] Q_out[431] Q_out[432] Q_out[433] Q_out[434] Q_out[435] Q_out[436] Q_out[437] Q_out[438] Q_out[439]
+ Q_out[440] Q_out[441] Q_out[442] Q_out[443] Q_out[444] Q_out[445] Q_out[446] Q_out[447] Q_out[448] Q_out[449] Q_out[450] Q_out[451]
+ Q_out[452] Q_out[453] Q_out[454] Q_out[455] Q_out[456] Q_out[457] Q_out[458] Q_out[459] Q_out[460] Q_out[461] Q_out[462] Q_out[463]
+ Q_out[464] Q_out[465] Q_out[466] Q_out[467] Q_out[468] Q_out[469] Q_out[470] Q_out[471] Q_out[472] Q_out[473] Q_out[474] Q_out[475]
+ Q_out[476] Q_out[477] Q_out[478] Q_out[479] Q_out[480] Q_out[481] Q_out[482] Q_out[483] Q_out[484] Q_out[485] Q_out[486] Q_out[487]
+ Q_out[488] Q_out[489] Q_out[490] Q_out[491] Q_out[492] Q_out[493] Q_out[494] Q_out[495] Q_out[496] Q_out[497] Q_out[498] Q_out[499]
+ Q_out[500] Q_out[501] Q_out[502] Q_out[503] Q_out[504] Q_out[505] Q_out[506] Q_out[507] Q_out[508] Q_out[509] Q_out[510] Q_out[511]
+ Q_out[512] Q_out[513] Q_out[514] Q_out[515] Q_out[516] Q_out[517] Q_out[518] Q_out[519] Q_out[520] Q_out[521] Q_out[522] Q_out[523]
+ Q_out[524] Q_out[525] Q_out[526] Q_out[527] Q_out[528] Q_out[529] Q_out[530] Q_out[531] Q_out[532] Q_out[533] Q_out[534] Q_out[535]
+ Q_out[536] Q_out[537] Q_out[538] Q_out[539] Q_out[540] Q_out[541] Q_out[542] Q_out[543] Q_out[544] Q_out[545] Q_out[546] Q_out[547]
+ Q_out[548] Q_out[549] Q_out[550] Q_out[551] Q_out[552] Q_out[553] Q_out[554] Q_out[555] Q_out[556] Q_out[557] Q_out[558] Q_out[559]
+ Q_out[560] Q_out[561] Q_out[562] Q_out[563] Q_out[564] Q_out[565] Q_out[566] Q_out[567] Q_out[568] Q_out[569] Q_out[570] Q_out[571]
+ Q_out[572] Q_out[573] Q_out[574] Q_out[575] Q_out[576] Q_out[577] Q_out[578] Q_out[579] Q_out[580] Q_out[581] Q_out[582] Q_out[583]
+ Q_out[584] Q_out[585] Q_out[586] Q_out[587] Q_out[588] Q_out[589] Q_out[590] Q_out[591] Q_out[592] Q_out[593] Q_out[594] Q_out[595]
+ Q_out[596] Q_out[597] Q_out[598] Q_out[599] Q_out[600] Q_out[601] Q_out[602] Q_out[603] Q_out[604] Q_out[605] Q_out[606] Q_out[607]
+ Q_out[608] Q_out[609] Q_out[610] Q_out[611] Q_out[612] Q_out[613] Q_out[614] Q_out[615] Q_out[616] Q_out[617] Q_out[618] Q_out[619]
+ Q_out[620] Q_out[621] Q_out[622] Q_out[623] Q_out[624] Q_out[625] Q_out[626] Q_out[627] Q_out[628] Q_out[629] Q_out[630] Q_out[631]
+ Q_out[632] Q_out[633] Q_out[634] Q_out[635] Q_out[636] Q_out[637] Q_out[638] Q_out[639] Q_out[640] Q_out[641] Q_out[642] Q_out[643]
+ Q_out[644] Q_out[645] Q_out[646] Q_out[647] Q_out[648] Q_out[649] Q_out[650] Q_out[651] Q_out[652] Q_out[653] Q_out[654] Q_out[655]
+ Q_out[656] Q_out[657] Q_out[658] Q_out[659] Q_out[660] Q_out[661] Q_out[662] Q_out[663] Q_out[664] Q_out[665] Q_out[666] Q_out[667]
+ Q_out[668] Q_out[669] Q_out[670] Q_out[671] Q_out[672] Q_out[673] Q_out[674] Q_out[675] Q_out[676] Q_out[677] Q_out[678] Q_out[679]
+ Q_out[680] Q_out[681] Q_out[682] Q_out[683] Q_out[684] Q_out[685] Q_out[686] Q_out[687] Q_out[688] Q_out[689] Q_out[690] Q_out[691]
+ Q_out[692] Q_out[693] Q_out[694] Q_out[695] Q_out[696] Q_out[697] Q_out[698] Q_out[699] Q_out[700] Q_out[701] Q_out[702] Q_out[703]
+ Q_out[704] Q_out[705] Q_out[706] Q_out[707] Q_out[708] Q_out[709] Q_out[710] Q_out[711] Q_out[712] Q_out[713] Q_out[714] Q_out[715]
+ Q_out[716] Q_out[717] Q_out[718] Q_out[719] Q_out[720] Q_out[721] Q_out[722] Q_out[723] Q_out[724] Q_out[725] Q_out[726] Q_out[727]
+ Q_out[728] Q_out[729] Q_out[730] Q_out[731] Q_out[732] Q_out[733] Q_out[734] Q_out[735] Q_out[736] Q_out[737] Q_out[738] Q_out[739]
+ Q_out[740] Q_out[741] Q_out[742] Q_out[743] Q_out[744] Q_out[745] Q_out[746] Q_out[747] Q_out[748] Q_out[749] Q_out[750] Q_out[751]
+ Q_out[752] Q_out[753] Q_out[754] Q_out[755] Q_out[756] Q_out[757] Q_out[758] Q_out[759] Q_out[760] Q_out[761] Q_out[762] Q_out[763]
+ Q_out[764] Q_out[765] Q_out[766] Q_out[767] Q_out[768] Q_out[769] Q_out[770] Q_out[771] Q_out[772] Q_out[773] Q_out[774] Q_out[775]
+ Q_out[776] Q_out[777] Q_out[778] Q_out[779] Q_out[780] Q_out[781] Q_out[782] Q_out[783] Q_out[784] Q_out[785] Q_out[786] Q_out[787]
+ Q_out[788] Q_out[789] Q_out[790] Q_out[791] Q_out[792] Q_out[793] Q_out[794] Q_out[795] Q_out[796] Q_out[797] Q_out[798] Q_out[799]
+ Q_out[800] Q_out[801] Q_out[802] Q_out[803] Q_out[804] Q_out[805] Q_out[806] Q_out[807] Q_out[808] Q_out[809] Q_out[810] Q_out[811]
+ Q_out[812] Q_out[813] Q_out[814] Q_out[815] Q_out[816] Q_out[817] Q_out[818] Q_out[819] Q_out[820] Q_out[821] Q_out[822] Q_out[823]
+ Q_out[824] Q_out[825] Q_out[826] Q_out[827] Q_out[828] Q_out[829] Q_out[830] Q_out[831] Q_out[832] Q_out[833] Q_out[834] Q_out[835]
+ Q_out[836] Q_out[837] Q_out[838] Q_out[839] Q_out[840] Q_out[841] Q_out[842] Q_out[843] Q_out[844] Q_out[845] Q_out[846] Q_out[847]
+ Q_out[848] Q_out[849] Q_out[850] Q_out[851] Q_out[852] Q_out[853] Q_out[854] Q_out[855] Q_out[856] Q_out[857] Q_out[858] Q_out[859]
+ Q_out[860] Q_out[861] Q_out[862] Q_out[863] Q_out[864] Q_out[865] Q_out[866] Q_out[867] Q_out[868] Q_out[869] Q_out[870] Q_out[871]
+ Q_out[872] Q_out[873] Q_out[874] Q_out[875] Q_out[876] Q_out[877] Q_out[878] Q_out[879] Q_out[880] Q_out[881] Q_out[882] Q_out[883]
+ Q_out[884] Q_out[885] Q_out[886] Q_out[887] Q_out[888] Q_out[889] Q_out[890] Q_out[891] Q_out[892] Q_out[893] Q_out[894] Q_out[895]
+ Q_out[896] Q_out[897] Q_out[898] Q_out[899] Q_out[900] Q_out[901] Q_out[902] Q_out[903] Q_out[904] Q_out[905] Q_out[906] Q_out[907]
+ Q_out[908] Q_out[909] Q_out[910] Q_out[911] Q_out[912] Q_out[913] Q_out[914] Q_out[915] Q_out[916] Q_out[917] Q_out[918] Q_out[919]
+ Q_out[920] Q_out[921] Q_out[922] Q_out[923] Q_out[924] Q_out[925] Q_out[926] Q_out[927] Q_out[928] Q_out[929] Q_out[930] Q_out[931]
+ Q_out[932] Q_out[933] Q_out[934] Q_out[935] Q_out[936] Q_out[937] Q_out[938] Q_out[939] Q_out[940] Q_out[941] Q_out[942] Q_out[943]
+ Q_out[944] Q_out[945] Q_out[946] Q_out[947] Q_out[948] Q_out[949] Q_out[950] Q_out[951] Q_out[952] Q_out[953] Q_out[954] Q_out[955]
+ Q_out[956] Q_out[957] Q_out[958] Q_out[959] Q_out[960] Q_out[961] Q_out[962] Q_out[963] Q_out[964] Q_out[965] Q_out[966] Q_out[967]
+ Q_out[968] Q_out[969] Q_out[970] Q_out[971] Q_out[972] Q_out[973] Q_out[974] Q_out[975] Q_out[976] Q_out[977] Q_out[978] Q_out[979]
+ Q_out[980] Q_out[981] Q_out[982] Q_out[983] Q_out[984] Q_out[985] Q_out[986] Q_out[987] Q_out[988] Q_out[989] Q_out[990] Q_out[991]
+ Q_out[992] Q_out[993] Q_out[994] Q_out[995] Q_out[996] Q_out[997] Q_out[998] Q_out[999] Q_out[1000] Q_out[1001] Q_out[1002] Q_out[1003]
+ Q_out[1004] Q_out[1005] Q_out[1006] Q_out[1007] Q_out[1008] Q_out[1009] Q_out[1010] Q_out[1011] Q_out[1012] Q_out[1013] Q_out[1014]
+ Q_out[1015] Q_out[1016] Q_out[1017] Q_out[1018] Q_out[1019] Q_out[1020] Q_out[1021] Q_out[1022] Q_out[1023] Q_out[1024] Q_out[1025]
+ Q_out[1026] Q_out[1027] Q_out[1028] Q_out[1029] Q_out[1030] Q_out[1031] Q_out[1032] Q_out[1033] Q_out[1034] Q_out[1035] Q_out[1036]
+ Q_out[1037] Q_out[1038] Q_out[1039] Q_out[1040] Q_out[1041] Q_out[1042] Q_out[1043] Q_out[1044] Q_out[1045] Q_out[1046] Q_out[1047]
+ Q_out[1048] Q_out[1049] Q_out[1050] Q_out[1051] Q_out[1052] Q_out[1053] Q_out[1054] Q_out[1055] Q_out[1056] Q_out[1057] Q_out[1058]
+ Q_out[1059] Q_out[1060] Q_out[1061] Q_out[1062] Q_out[1063] Q_out[1064] Q_out[1065] Q_out[1066] Q_out[1067] Q_out[1068] Q_out[1069]
+ Q_out[1070] Q_out[1071] Q_out[1072] Q_out[1073] Q_out[1074] Q_out[1075] Q_out[1076] Q_out[1077] Q_out[1078] Q_out[1079] Q_out[1080]
+ Q_out[1081] Q_out[1082] Q_out[1083] Q_out[1084] Q_out[1085] Q_out[1086] Q_out[1087] Q_out[1088] Q_out[1089] Q_out[1090] Q_out[1091]
+ Q_out[1092] Q_out[1093] Q_out[1094] Q_out[1095] Q_out[1096] Q_out[1097] Q_out[1098] Q_out[1099] Q_out[1100] Q_out[1101] Q_out[1102]
+ Q_out[1103] Q_out[1104] Q_out[1105] Q_out[1106] Q_out[1107] Q_out[1108] Q_out[1109] Q_out[1110] Q_out[1111] Q_out[1112] Q_out[1113]
+ Q_out[1114] Q_out[1115] Q_out[1116] Q_out[1117] Q_out[1118] Q_out[1119] Q_out[1120] Q_out[1121] Q_out[1122] Q_out[1123] Q_out[1124]
+ Q_out[1125] Q_out[1126] Q_out[1127] Q_out[1128] Q_out[1129] Q_out[1130] Q_out[1131] Q_out[1132] Q_out[1133] Q_out[1134] Q_out[1135]
+ Q_out[1136] Q_out[1137] Q_out[1138] Q_out[1139] Q_out[1140] Q_out[1141] Q_out[1142] Q_out[1143] Q_out[1144] Q_out[1145] Q_out[1146]
+ Q_out[1147] Q_out[1148] Q_out[1149] Q_out[1150] Q_out[1151] Q_out[1152] Q_out[1153] Q_out[1154] Q_out[1155] Q_out[1156] Q_out[1157]
+ Q_out[1158] Q_out[1159] Q_out[1160] Q_out[1161] Q_out[1162] Q_out[1163] Q_out[1164] Q_out[1165] Q_out[1166] Q_out[1167] Q_out[1168]
+ Q_out[1169] Q_out[1170] Q_out[1171] Q_out[1172] Q_out[1173] Q_out[1174] Q_out[1175] Q_out[1176] Q_out[1177] Q_out[1178] Q_out[1179]
+ Q_out[1180] Q_out[1181] Q_out[1182] Q_out[1183] Q_out[1184] Q_out[1185] Q_out[1186] Q_out[1187] Q_out[1188] Q_out[1189] Q_out[1190]
+ Q_out[1191] Q_out[1192] Q_out[1193] Q_out[1194] Q_out[1195] Q_out[1196] Q_out[1197] Q_out[1198] Q_out[1199] Q_out[1200] Q_out[1201]
+ Q_out[1202] Q_out[1203] Q_out[1204] Q_out[1205] Q_out[1206] Q_out[1207] Q_out[1208] Q_out[1209] Q_out[1210] Q_out[1211] Q_out[1212]
+ Q_out[1213] Q_out[1214] Q_out[1215] Q_out[1216] Q_out[1217] Q_out[1218] Q_out[1219] Q_out[1220] Q_out[1221] Q_out[1222] Q_out[1223]
+ Q_out[1224] Q_out[1225] Q_out[1226] Q_out[1227] Q_out[1228] Q_out[1229] Q_out[1230] Q_out[1231] Q_out[1232] Q_out[1233] Q_out[1234]
+ Q_out[1235] Q_out[1236] Q_out[1237] Q_out[1238] Q_out[1239] Q_out[1240] Q_out[1241] Q_out[1242] Q_out[1243] Q_out[1244] Q_out[1245]
+ Q_out[1246] Q_out[1247] Q_out[1248] Q_out[1249] Q_out[1250] Q_out[1251] Q_out[1252] Q_out[1253] Q_out[1254] Q_out[1255] Q_out[1256]
+ Q_out[1257] Q_out[1258] Q_out[1259] Q_out[1260] Q_out[1261] Q_out[1262] Q_out[1263] Q_out[1264] Q_out[1265] Q_out[1266] Q_out[1267]
+ Q_out[1268] Q_out[1269] Q_out[1270] Q_out[1271] Q_out[1272] Q_out[1273] Q_out[1274] Q_out[1275] Q_out[1276] Q_out[1277] Q_out[1278]
+ Q_out[1279] Q_out[1280] Q_out[1281] Q_out[1282] Q_out[1283] Q_out[1284] Q_out[1285] Q_out[1286] Q_out[1287] Q_out[1288] Q_out[1289]
+ Q_out[1290] Q_out[1291] Q_out[1292] Q_out[1293] Q_out[1294] Q_out[1295] Q_out[1296] Q_out[1297] Q_out[1298] Q_out[1299] Q_out[1300]
+ Q_out[1301] Q_out[1302] Q_out[1303] Q_out[1304] Q_out[1305] Q_out[1306] Q_out[1307] Q_out[1308] Q_out[1309] Q_out[1310] Q_out[1311]
+ Q_out[1312] Q_out[1313] Q_out[1314] Q_out[1315] Q_out[1316] Q_out[1317] Q_out[1318] Q_out[1319] Q_out[1320] Q_out[1321] Q_out[1322]
+ Q_out[1323] Q_out[1324] Q_out[1325] Q_out[1326] Q_out[1327] Q_out[1328] Q_out[1329] Q_out[1330] Q_out[1331] Q_out[1332] Q_out[1333]
+ Q_out[1334] Q_out[1335] Q_out[1336] Q_out[1337] Q_out[1338] Q_out[1339] Q_out[1340] Q_out[1341] Q_out[1342] Q_out[1343] Q_out[1344]
+ Q_out[1345] Q_out[1346] Q_out[1347] Q_out[1348] Q_out[1349] Q_out[1350] Q_out[1351] Q_out[1352] Q_out[1353] Q_out[1354] Q_out[1355]
+ Q_out[1356] Q_out[1357] Q_out[1358] Q_out[1359] Q_out[1360] Q_out[1361] Q_out[1362] Q_out[1363] Q_out[1364] Q_out[1365] Q_out[1366]
+ Q_out[1367] Q_out[1368] Q_out[1369] Q_out[1370] Q_out[1371] Q_out[1372] Q_out[1373] Q_out[1374] Q_out[1375] Q_out[1376] Q_out[1377]
+ Q_out[1378] Q_out[1379] Q_out[1380] Q_out[1381] Q_out[1382] Q_out[1383] Q_out[1384] Q_out[1385] Q_out[1386] Q_out[1387] Q_out[1388]
+ Q_out[1389] Q_out[1390] Q_out[1391] Q_out[1392] Q_out[1393] Q_out[1394] Q_out[1395] Q_out[1396] Q_out[1397] Q_out[1398] Q_out[1399]
+ Q_out[1400] Q_out[1401] Q_out[1402] Q_out[1403] Q_out[1404] Q_out[1405] Q_out[1406] Q_out[1407] Q_out[1408] Q_out[1409] Q_out[1410]
+ Q_out[1411] Q_out[1412] Q_out[1413] Q_out[1414] Q_out[1415] Q_out[1416] Q_out[1417] Q_out[1418] Q_out[1419] Q_out[1420] Q_out[1421]
+ Q_out[1422] Q_out[1423] Q_out[1424] Q_out[1425] Q_out[1426] Q_out[1427] Q_out[1428] Q_out[1429] Q_out[1430] Q_out[1431] Q_out[1432]
+ Q_out[1433] Q_out[1434] Q_out[1435] Q_out[1436] Q_out[1437] Q_out[1438] Q_out[1439] Q_out[1440] Q_out[1441] Q_out[1442] Q_out[1443]
+ Q_out[1444] Q_out[1445] Q_out[1446] Q_out[1447] Q_out[1448] Q_out[1449] Q_out[1450] Q_out[1451] Q_out[1452] Q_out[1453] Q_out[1454]
+ Q_out[1455] Q_out[1456] Q_out[1457] Q_out[1458] Q_out[1459] Q_out[1460] Q_out[1461] Q_out[1462] Q_out[1463] Q_out[1464] Q_out[1465]
+ Q_out[1466] Q_out[1467] Q_out[1468] Q_out[1469] Q_out[1470] Q_out[1471] Q_out[1472] Q_out[1473] Q_out[1474] Q_out[1475] Q_out[1476]
+ Q_out[1477] Q_out[1478] Q_out[1479] Q_out[1480] Q_out[1481] Q_out[1482] Q_out[1483] Q_out[1484] Q_out[1485] Q_out[1486] Q_out[1487]
+ Q_out[1488] D_out_row[1] D_out_row[2] D_out_row[3] D_out_row[4] D_out_row[5] D_out_row[6] D_out_row[7] D_out_row[8] D_out_row[9]
+ D_out_row[10] D_out_row[11] D_out_row[12] D_out_row[13] D_out_row[14] D_out_row[15] D_out_row[16] D_out_row[17] D_out_row[18] D_out_row[19]
+ D_out_row[20] D_out_row[21] D_out_row[22] D_out_row[23] D_out_row[24] D_out_row[25] D_out_row[26] D_out_row[27] D_out_row[28] D_out_row[29]
+ D_out_row[30] D_out_row[31] D_out_row[32] D_out_row[33] D_out_row[34] D_out_row[35] D_out_row[36] D_out_row[37] D_out_row[38] D_out_row[39]
+ D_out_row[40] D_out_row[41] D_out_row[42] D_out_row[43] D_out_row[44] D_out_row[45] D_out_row[46] D_out_row[47] D_out_row[48] D_out_row[49]
+ D_out_row[50] D_out_row[51] D_out_row[52] D_out_row[53] D_out_row[54] D_out_row[55] D_out_row[56] D_out_row[57] D_out_row[58] D_out_row[59]
+ D_out_row[60] D_out_row[61] swmatrix_62_by_25
xDIG_and_CLKGEN data data_in clock net1 net2 enable net3 VDDd VSSd digital_interface_and_clock_gen
x1 PHI_1_in net1 VDDd VSSd PHI_CLK_buf
x2 PHI_2_in net2 VDDd VSSd PHI_CLK_buf
xSWMATRIX2 D_out1 D_out PHI_1_in PHI_2_in BUS[1] BUS[2] BUS[3] BUS[4] BUS[5] BUS[6] BUS[7] BUS[8] BUS[9] BUS[10] BUS[11] BUS[12]
+ BUS[13] BUS[14] BUS[15] BUS[16] BUS[17] BUS[18] BUS[19] BUS[20] BUS[21] BUS[22] BUS[23] BUS[24] BUS[25] PIN[63] PIN[64] PIN[65] PIN[66]
+ PIN[67] PIN[68] PIN[69] PIN[70] PIN[71] PIN[72] PIN[73] PIN[74] PIN[75] PIN[76] PIN[77] PIN[78] PIN[79] PIN[80] PIN[81] PIN[82] PIN[83]
+ PIN[84] PIN[85] PIN[86] PIN[87] PIN[88] PIN[89] PIN[90] PIN[91] PIN[92] PIN[93] PIN[94] PIN[95] PIN[96] PIN[97] PIN[98] PIN[99] PIN[100]
+ PIN[101] PIN[102] PIN[103] PIN[104] PIN[105] PIN[106] PIN[107] PIN[108] PIN[109] PIN[110] PIN[111] PIN[112] PIN[113] PIN[114] PIN[115]
+ PIN[116] PIN[117] PIN[118] PIN[119] PIN[120] PIN[121] PIN[122] PIN[123] PIN[124] PIN[125] PIN[126] PIN[127] PIN[128] PIN[129] PIN[130]
+ VDDd VSSd enable_in Q_out2[1] Q_out2[2] Q_out2[3] Q_out2[4] Q_out2[5] Q_out2[6] Q_out2[7] Q_out2[8] Q_out2[9] Q_out2[10] Q_out2[11]
+ Q_out2[12] Q_out2[13] Q_out2[14] Q_out2[15] Q_out2[16] Q_out2[17] Q_out2[18] Q_out2[19] Q_out2[20] Q_out2[21] Q_out2[22] Q_out2[23]
+ Q_out2[24] Q_out2[25] Q_out2[26] Q_out2[27] Q_out2[28] Q_out2[29] Q_out2[30] Q_out2[31] Q_out2[32] Q_out2[33] Q_out2[34] Q_out2[35]
+ Q_out2[36] Q_out2[37] Q_out2[38] Q_out2[39] Q_out2[40] Q_out2[41] Q_out2[42] Q_out2[43] Q_out2[44] Q_out2[45] Q_out2[46] Q_out2[47]
+ Q_out2[48] Q_out2[49] Q_out2[50] Q_out2[51] Q_out2[52] Q_out2[53] Q_out2[54] Q_out2[55] Q_out2[56] Q_out2[57] Q_out2[58] Q_out2[59]
+ Q_out2[60] Q_out2[61] Q_out2[62] Q_out2[63] Q_out2[64] Q_out2[65] Q_out2[66] Q_out2[67] Q_out2[68] Q_out2[69] Q_out2[70] Q_out2[71]
+ Q_out2[72] Q_out2[73] Q_out2[74] Q_out2[75] Q_out2[76] Q_out2[77] Q_out2[78] Q_out2[79] Q_out2[80] Q_out2[81] Q_out2[82] Q_out2[83]
+ Q_out2[84] Q_out2[85] Q_out2[86] Q_out2[87] Q_out2[88] Q_out2[89] Q_out2[90] Q_out2[91] Q_out2[92] Q_out2[93] Q_out2[94] Q_out2[95]
+ Q_out2[96] Q_out2[97] Q_out2[98] Q_out2[99] Q_out2[100] Q_out2[101] Q_out2[102] Q_out2[103] Q_out2[104] Q_out2[105] Q_out2[106] Q_out2[107]
+ Q_out2[108] Q_out2[109] Q_out2[110] Q_out2[111] Q_out2[112] Q_out2[113] Q_out2[114] Q_out2[115] Q_out2[116] Q_out2[117] Q_out2[118]
+ Q_out2[119] Q_out2[120] Q_out2[121] Q_out2[122] Q_out2[123] Q_out2[124] Q_out2[125] Q_out2[126] Q_out2[127] Q_out2[128] Q_out2[129]
+ Q_out2[130] Q_out2[131] Q_out2[132] Q_out2[133] Q_out2[134] Q_out2[135] Q_out2[136] Q_out2[137] Q_out2[138] Q_out2[139] Q_out2[140]
+ Q_out2[141] Q_out2[142] Q_out2[143] Q_out2[144] Q_out2[145] Q_out2[146] Q_out2[147] Q_out2[148] Q_out2[149] Q_out2[150] Q_out2[151]
+ Q_out2[152] Q_out2[153] Q_out2[154] Q_out2[155] Q_out2[156] Q_out2[157] Q_out2[158] Q_out2[159] Q_out2[160] Q_out2[161] Q_out2[162]
+ Q_out2[163] Q_out2[164] Q_out2[165] Q_out2[166] Q_out2[167] Q_out2[168] Q_out2[169] Q_out2[170] Q_out2[171] Q_out2[172] Q_out2[173]
+ Q_out2[174] Q_out2[175] Q_out2[176] Q_out2[177] Q_out2[178] Q_out2[179] Q_out2[180] Q_out2[181] Q_out2[182] Q_out2[183] Q_out2[184]
+ Q_out2[185] Q_out2[186] Q_out2[187] Q_out2[188] Q_out2[189] Q_out2[190] Q_out2[191] Q_out2[192] Q_out2[193] Q_out2[194] Q_out2[195]
+ Q_out2[196] Q_out2[197] Q_out2[198] Q_out2[199] Q_out2[200] Q_out2[201] Q_out2[202] Q_out2[203] Q_out2[204] Q_out2[205] Q_out2[206]
+ Q_out2[207] Q_out2[208] Q_out2[209] Q_out2[210] Q_out2[211] Q_out2[212] Q_out2[213] Q_out2[214] Q_out2[215] Q_out2[216] Q_out2[217]
+ Q_out2[218] Q_out2[219] Q_out2[220] Q_out2[221] Q_out2[222] Q_out2[223] Q_out2[224] Q_out2[225] Q_out2[226] Q_out2[227] Q_out2[228]
+ Q_out2[229] Q_out2[230] Q_out2[231] Q_out2[232] Q_out2[233] Q_out2[234] Q_out2[235] Q_out2[236] Q_out2[237] Q_out2[238] Q_out2[239]
+ Q_out2[240] Q_out2[241] Q_out2[242] Q_out2[243] Q_out2[244] Q_out2[245] Q_out2[246] Q_out2[247] Q_out2[248] Q_out2[249] Q_out2[250]
+ Q_out2[251] Q_out2[252] Q_out2[253] Q_out2[254] Q_out2[255] Q_out2[256] Q_out2[257] Q_out2[258] Q_out2[259] Q_out2[260] Q_out2[261]
+ Q_out2[262] Q_out2[263] Q_out2[264] Q_out2[265] Q_out2[266] Q_out2[267] Q_out2[268] Q_out2[269] Q_out2[270] Q_out2[271] Q_out2[272]
+ Q_out2[273] Q_out2[274] Q_out2[275] Q_out2[276] Q_out2[277] Q_out2[278] Q_out2[279] Q_out2[280] Q_out2[281] Q_out2[282] Q_out2[283]
+ Q_out2[284] Q_out2[285] Q_out2[286] Q_out2[287] Q_out2[288] Q_out2[289] Q_out2[290] Q_out2[291] Q_out2[292] Q_out2[293] Q_out2[294]
+ Q_out2[295] Q_out2[296] Q_out2[297] Q_out2[298] Q_out2[299] Q_out2[300] Q_out2[301] Q_out2[302] Q_out2[303] Q_out2[304] Q_out2[305]
+ Q_out2[306] Q_out2[307] Q_out2[308] Q_out2[309] Q_out2[310] Q_out2[311] Q_out2[312] Q_out2[313] Q_out2[314] Q_out2[315] Q_out2[316]
+ Q_out2[317] Q_out2[318] Q_out2[319] Q_out2[320] Q_out2[321] Q_out2[322] Q_out2[323] Q_out2[324] Q_out2[325] Q_out2[326] Q_out2[327]
+ Q_out2[328] Q_out2[329] Q_out2[330] Q_out2[331] Q_out2[332] Q_out2[333] Q_out2[334] Q_out2[335] Q_out2[336] Q_out2[337] Q_out2[338]
+ Q_out2[339] Q_out2[340] Q_out2[341] Q_out2[342] Q_out2[343] Q_out2[344] Q_out2[345] Q_out2[346] Q_out2[347] Q_out2[348] Q_out2[349]
+ Q_out2[350] Q_out2[351] Q_out2[352] Q_out2[353] Q_out2[354] Q_out2[355] Q_out2[356] Q_out2[357] Q_out2[358] Q_out2[359] Q_out2[360]
+ Q_out2[361] Q_out2[362] Q_out2[363] Q_out2[364] Q_out2[365] Q_out2[366] Q_out2[367] Q_out2[368] Q_out2[369] Q_out2[370] Q_out2[371]
+ Q_out2[372] Q_out2[373] Q_out2[374] Q_out2[375] Q_out2[376] Q_out2[377] Q_out2[378] Q_out2[379] Q_out2[380] Q_out2[381] Q_out2[382]
+ Q_out2[383] Q_out2[384] Q_out2[385] Q_out2[386] Q_out2[387] Q_out2[388] Q_out2[389] Q_out2[390] Q_out2[391] Q_out2[392] Q_out2[393]
+ Q_out2[394] Q_out2[395] Q_out2[396] Q_out2[397] Q_out2[398] Q_out2[399] Q_out2[400] Q_out2[401] Q_out2[402] Q_out2[403] Q_out2[404]
+ Q_out2[405] Q_out2[406] Q_out2[407] Q_out2[408] Q_out2[409] Q_out2[410] Q_out2[411] Q_out2[412] Q_out2[413] Q_out2[414] Q_out2[415]
+ Q_out2[416] Q_out2[417] Q_out2[418] Q_out2[419] Q_out2[420] Q_out2[421] Q_out2[422] Q_out2[423] Q_out2[424] Q_out2[425] Q_out2[426]
+ Q_out2[427] Q_out2[428] Q_out2[429] Q_out2[430] Q_out2[431] Q_out2[432] Q_out2[433] Q_out2[434] Q_out2[435] Q_out2[436] Q_out2[437]
+ Q_out2[438] Q_out2[439] Q_out2[440] Q_out2[441] Q_out2[442] Q_out2[443] Q_out2[444] Q_out2[445] Q_out2[446] Q_out2[447] Q_out2[448]
+ Q_out2[449] Q_out2[450] Q_out2[451] Q_out2[452] Q_out2[453] Q_out2[454] Q_out2[455] Q_out2[456] Q_out2[457] Q_out2[458] Q_out2[459]
+ Q_out2[460] Q_out2[461] Q_out2[462] Q_out2[463] Q_out2[464] Q_out2[465] Q_out2[466] Q_out2[467] Q_out2[468] Q_out2[469] Q_out2[470]
+ Q_out2[471] Q_out2[472] Q_out2[473] Q_out2[474] Q_out2[475] Q_out2[476] Q_out2[477] Q_out2[478] Q_out2[479] Q_out2[480] Q_out2[481]
+ Q_out2[482] Q_out2[483] Q_out2[484] Q_out2[485] Q_out2[486] Q_out2[487] Q_out2[488] Q_out2[489] Q_out2[490] Q_out2[491] Q_out2[492]
+ Q_out2[493] Q_out2[494] Q_out2[495] Q_out2[496] Q_out2[497] Q_out2[498] Q_out2[499] Q_out2[500] Q_out2[501] Q_out2[502] Q_out2[503]
+ Q_out2[504] Q_out2[505] Q_out2[506] Q_out2[507] Q_out2[508] Q_out2[509] Q_out2[510] Q_out2[511] Q_out2[512] Q_out2[513] Q_out2[514]
+ Q_out2[515] Q_out2[516] Q_out2[517] Q_out2[518] Q_out2[519] Q_out2[520] Q_out2[521] Q_out2[522] Q_out2[523] Q_out2[524] Q_out2[525]
+ Q_out2[526] Q_out2[527] Q_out2[528] Q_out2[529] Q_out2[530] Q_out2[531] Q_out2[532] Q_out2[533] Q_out2[534] Q_out2[535] Q_out2[536]
+ Q_out2[537] Q_out2[538] Q_out2[539] Q_out2[540] Q_out2[541] Q_out2[542] Q_out2[543] Q_out2[544] Q_out2[545] Q_out2[546] Q_out2[547]
+ Q_out2[548] Q_out2[549] Q_out2[550] Q_out2[551] Q_out2[552] Q_out2[553] Q_out2[554] Q_out2[555] Q_out2[556] Q_out2[557] Q_out2[558]
+ Q_out2[559] Q_out2[560] Q_out2[561] Q_out2[562] Q_out2[563] Q_out2[564] Q_out2[565] Q_out2[566] Q_out2[567] Q_out2[568] Q_out2[569]
+ Q_out2[570] Q_out2[571] Q_out2[572] Q_out2[573] Q_out2[574] Q_out2[575] Q_out2[576] Q_out2[577] Q_out2[578] Q_out2[579] Q_out2[580]
+ Q_out2[581] Q_out2[582] Q_out2[583] Q_out2[584] Q_out2[585] Q_out2[586] Q_out2[587] Q_out2[588] Q_out2[589] Q_out2[590] Q_out2[591]
+ Q_out2[592] Q_out2[593] Q_out2[594] Q_out2[595] Q_out2[596] Q_out2[597] Q_out2[598] Q_out2[599] Q_out2[600] Q_out2[601] Q_out2[602]
+ Q_out2[603] Q_out2[604] Q_out2[605] Q_out2[606] Q_out2[607] Q_out2[608] Q_out2[609] Q_out2[610] Q_out2[611] Q_out2[612] Q_out2[613]
+ Q_out2[614] Q_out2[615] Q_out2[616] Q_out2[617] Q_out2[618] Q_out2[619] Q_out2[620] Q_out2[621] Q_out2[622] Q_out2[623] Q_out2[624]
+ Q_out2[625] Q_out2[626] Q_out2[627] Q_out2[628] Q_out2[629] Q_out2[630] Q_out2[631] Q_out2[632] Q_out2[633] Q_out2[634] Q_out2[635]
+ Q_out2[636] Q_out2[637] Q_out2[638] Q_out2[639] Q_out2[640] Q_out2[641] Q_out2[642] Q_out2[643] Q_out2[644] Q_out2[645] Q_out2[646]
+ Q_out2[647] Q_out2[648] Q_out2[649] Q_out2[650] Q_out2[651] Q_out2[652] Q_out2[653] Q_out2[654] Q_out2[655] Q_out2[656] Q_out2[657]
+ Q_out2[658] Q_out2[659] Q_out2[660] Q_out2[661] Q_out2[662] Q_out2[663] Q_out2[664] Q_out2[665] Q_out2[666] Q_out2[667] Q_out2[668]
+ Q_out2[669] Q_out2[670] Q_out2[671] Q_out2[672] Q_out2[673] Q_out2[674] Q_out2[675] Q_out2[676] Q_out2[677] Q_out2[678] Q_out2[679]
+ Q_out2[680] Q_out2[681] Q_out2[682] Q_out2[683] Q_out2[684] Q_out2[685] Q_out2[686] Q_out2[687] Q_out2[688] Q_out2[689] Q_out2[690]
+ Q_out2[691] Q_out2[692] Q_out2[693] Q_out2[694] Q_out2[695] Q_out2[696] Q_out2[697] Q_out2[698] Q_out2[699] Q_out2[700] Q_out2[701]
+ Q_out2[702] Q_out2[703] Q_out2[704] Q_out2[705] Q_out2[706] Q_out2[707] Q_out2[708] Q_out2[709] Q_out2[710] Q_out2[711] Q_out2[712]
+ Q_out2[713] Q_out2[714] Q_out2[715] Q_out2[716] Q_out2[717] Q_out2[718] Q_out2[719] Q_out2[720] Q_out2[721] Q_out2[722] Q_out2[723]
+ Q_out2[724] Q_out2[725] Q_out2[726] Q_out2[727] Q_out2[728] Q_out2[729] Q_out2[730] Q_out2[731] Q_out2[732] Q_out2[733] Q_out2[734]
+ Q_out2[735] Q_out2[736] Q_out2[737] Q_out2[738] Q_out2[739] Q_out2[740] Q_out2[741] Q_out2[742] Q_out2[743] Q_out2[744] Q_out2[745]
+ Q_out2[746] Q_out2[747] Q_out2[748] Q_out2[749] Q_out2[750] Q_out2[751] Q_out2[752] Q_out2[753] Q_out2[754] Q_out2[755] Q_out2[756]
+ Q_out2[757] Q_out2[758] Q_out2[759] Q_out2[760] Q_out2[761] Q_out2[762] Q_out2[763] Q_out2[764] Q_out2[765] Q_out2[766] Q_out2[767]
+ Q_out2[768] Q_out2[769] Q_out2[770] Q_out2[771] Q_out2[772] Q_out2[773] Q_out2[774] Q_out2[775] Q_out2[776] Q_out2[777] Q_out2[778]
+ Q_out2[779] Q_out2[780] Q_out2[781] Q_out2[782] Q_out2[783] Q_out2[784] Q_out2[785] Q_out2[786] Q_out2[787] Q_out2[788] Q_out2[789]
+ Q_out2[790] Q_out2[791] Q_out2[792] Q_out2[793] Q_out2[794] Q_out2[795] Q_out2[796] Q_out2[797] Q_out2[798] Q_out2[799] Q_out2[800]
+ Q_out2[801] Q_out2[802] Q_out2[803] Q_out2[804] Q_out2[805] Q_out2[806] Q_out2[807] Q_out2[808] Q_out2[809] Q_out2[810] Q_out2[811]
+ Q_out2[812] Q_out2[813] Q_out2[814] Q_out2[815] Q_out2[816] Q_out2[817] Q_out2[818] Q_out2[819] Q_out2[820] Q_out2[821] Q_out2[822]
+ Q_out2[823] Q_out2[824] Q_out2[825] Q_out2[826] Q_out2[827] Q_out2[828] Q_out2[829] Q_out2[830] Q_out2[831] Q_out2[832] Q_out2[833]
+ Q_out2[834] Q_out2[835] Q_out2[836] Q_out2[837] Q_out2[838] Q_out2[839] Q_out2[840] Q_out2[841] Q_out2[842] Q_out2[843] Q_out2[844]
+ Q_out2[845] Q_out2[846] Q_out2[847] Q_out2[848] Q_out2[849] Q_out2[850] Q_out2[851] Q_out2[852] Q_out2[853] Q_out2[854] Q_out2[855]
+ Q_out2[856] Q_out2[857] Q_out2[858] Q_out2[859] Q_out2[860] Q_out2[861] Q_out2[862] Q_out2[863] Q_out2[864] Q_out2[865] Q_out2[866]
+ Q_out2[867] Q_out2[868] Q_out2[869] Q_out2[870] Q_out2[871] Q_out2[872] Q_out2[873] Q_out2[874] Q_out2[875] Q_out2[876] Q_out2[877]
+ Q_out2[878] Q_out2[879] Q_out2[880] Q_out2[881] Q_out2[882] Q_out2[883] Q_out2[884] Q_out2[885] Q_out2[886] Q_out2[887] Q_out2[888]
+ Q_out2[889] Q_out2[890] Q_out2[891] Q_out2[892] Q_out2[893] Q_out2[894] Q_out2[895] Q_out2[896] Q_out2[897] Q_out2[898] Q_out2[899]
+ Q_out2[900] Q_out2[901] Q_out2[902] Q_out2[903] Q_out2[904] Q_out2[905] Q_out2[906] Q_out2[907] Q_out2[908] Q_out2[909] Q_out2[910]
+ Q_out2[911] Q_out2[912] Q_out2[913] Q_out2[914] Q_out2[915] Q_out2[916] Q_out2[917] Q_out2[918] Q_out2[919] Q_out2[920] Q_out2[921]
+ Q_out2[922] Q_out2[923] Q_out2[924] Q_out2[925] Q_out2[926] Q_out2[927] Q_out2[928] Q_out2[929] Q_out2[930] Q_out2[931] Q_out2[932]
+ Q_out2[933] Q_out2[934] Q_out2[935] Q_out2[936] Q_out2[937] Q_out2[938] Q_out2[939] Q_out2[940] Q_out2[941] Q_out2[942] Q_out2[943]
+ Q_out2[944] Q_out2[945] Q_out2[946] Q_out2[947] Q_out2[948] Q_out2[949] Q_out2[950] Q_out2[951] Q_out2[952] Q_out2[953] Q_out2[954]
+ Q_out2[955] Q_out2[956] Q_out2[957] Q_out2[958] Q_out2[959] Q_out2[960] Q_out2[961] Q_out2[962] Q_out2[963] Q_out2[964] Q_out2[965]
+ Q_out2[966] Q_out2[967] Q_out2[968] Q_out2[969] Q_out2[970] Q_out2[971] Q_out2[972] Q_out2[973] Q_out2[974] Q_out2[975] Q_out2[976]
+ Q_out2[977] Q_out2[978] Q_out2[979] Q_out2[980] Q_out2[981] Q_out2[982] Q_out2[983] Q_out2[984] Q_out2[985] Q_out2[986] Q_out2[987]
+ Q_out2[988] Q_out2[989] Q_out2[990] Q_out2[991] Q_out2[992] Q_out2[993] Q_out2[994] Q_out2[995] Q_out2[996] Q_out2[997] Q_out2[998]
+ Q_out2[999] Q_out2[1000] Q_out2[1001] Q_out2[1002] Q_out2[1003] Q_out2[1004] Q_out2[1005] Q_out2[1006] Q_out2[1007] Q_out2[1008] Q_out2[1009]
+ Q_out2[1010] Q_out2[1011] Q_out2[1012] Q_out2[1013] Q_out2[1014] Q_out2[1015] Q_out2[1016] Q_out2[1017] Q_out2[1018] Q_out2[1019] Q_out2[1020]
+ Q_out2[1021] Q_out2[1022] Q_out2[1023] Q_out2[1024] Q_out2[1025] Q_out2[1026] Q_out2[1027] Q_out2[1028] Q_out2[1029] Q_out2[1030] Q_out2[1031]
+ Q_out2[1032] Q_out2[1033] Q_out2[1034] Q_out2[1035] Q_out2[1036] Q_out2[1037] Q_out2[1038] Q_out2[1039] Q_out2[1040] Q_out2[1041] Q_out2[1042]
+ Q_out2[1043] Q_out2[1044] Q_out2[1045] Q_out2[1046] Q_out2[1047] Q_out2[1048] Q_out2[1049] Q_out2[1050] Q_out2[1051] Q_out2[1052] Q_out2[1053]
+ Q_out2[1054] Q_out2[1055] Q_out2[1056] Q_out2[1057] Q_out2[1058] Q_out2[1059] Q_out2[1060] Q_out2[1061] Q_out2[1062] Q_out2[1063] Q_out2[1064]
+ Q_out2[1065] Q_out2[1066] Q_out2[1067] Q_out2[1068] Q_out2[1069] Q_out2[1070] Q_out2[1071] Q_out2[1072] Q_out2[1073] Q_out2[1074] Q_out2[1075]
+ Q_out2[1076] Q_out2[1077] Q_out2[1078] Q_out2[1079] Q_out2[1080] Q_out2[1081] Q_out2[1082] Q_out2[1083] Q_out2[1084] Q_out2[1085] Q_out2[1086]
+ Q_out2[1087] Q_out2[1088] Q_out2[1089] Q_out2[1090] Q_out2[1091] Q_out2[1092] Q_out2[1093] Q_out2[1094] Q_out2[1095] Q_out2[1096] Q_out2[1097]
+ Q_out2[1098] Q_out2[1099] Q_out2[1100] Q_out2[1101] Q_out2[1102] Q_out2[1103] Q_out2[1104] Q_out2[1105] Q_out2[1106] Q_out2[1107] Q_out2[1108]
+ Q_out2[1109] Q_out2[1110] Q_out2[1111] Q_out2[1112] Q_out2[1113] Q_out2[1114] Q_out2[1115] Q_out2[1116] Q_out2[1117] Q_out2[1118] Q_out2[1119]
+ Q_out2[1120] Q_out2[1121] Q_out2[1122] Q_out2[1123] Q_out2[1124] Q_out2[1125] Q_out2[1126] Q_out2[1127] Q_out2[1128] Q_out2[1129] Q_out2[1130]
+ Q_out2[1131] Q_out2[1132] Q_out2[1133] Q_out2[1134] Q_out2[1135] Q_out2[1136] Q_out2[1137] Q_out2[1138] Q_out2[1139] Q_out2[1140] Q_out2[1141]
+ Q_out2[1142] Q_out2[1143] Q_out2[1144] Q_out2[1145] Q_out2[1146] Q_out2[1147] Q_out2[1148] Q_out2[1149] Q_out2[1150] Q_out2[1151] Q_out2[1152]
+ Q_out2[1153] Q_out2[1154] Q_out2[1155] Q_out2[1156] Q_out2[1157] Q_out2[1158] Q_out2[1159] Q_out2[1160] Q_out2[1161] Q_out2[1162] Q_out2[1163]
+ Q_out2[1164] Q_out2[1165] Q_out2[1166] Q_out2[1167] Q_out2[1168] Q_out2[1169] Q_out2[1170] Q_out2[1171] Q_out2[1172] Q_out2[1173] Q_out2[1174]
+ Q_out2[1175] Q_out2[1176] Q_out2[1177] Q_out2[1178] Q_out2[1179] Q_out2[1180] Q_out2[1181] Q_out2[1182] Q_out2[1183] Q_out2[1184] Q_out2[1185]
+ Q_out2[1186] Q_out2[1187] Q_out2[1188] Q_out2[1189] Q_out2[1190] Q_out2[1191] Q_out2[1192] Q_out2[1193] Q_out2[1194] Q_out2[1195] Q_out2[1196]
+ Q_out2[1197] Q_out2[1198] Q_out2[1199] Q_out2[1200] Q_out2[1201] Q_out2[1202] Q_out2[1203] Q_out2[1204] Q_out2[1205] Q_out2[1206] Q_out2[1207]
+ Q_out2[1208] Q_out2[1209] Q_out2[1210] Q_out2[1211] Q_out2[1212] Q_out2[1213] Q_out2[1214] Q_out2[1215] Q_out2[1216] Q_out2[1217] Q_out2[1218]
+ Q_out2[1219] Q_out2[1220] Q_out2[1221] Q_out2[1222] Q_out2[1223] Q_out2[1224] Q_out2[1225] Q_out2[1226] Q_out2[1227] Q_out2[1228] Q_out2[1229]
+ Q_out2[1230] Q_out2[1231] Q_out2[1232] Q_out2[1233] Q_out2[1234] Q_out2[1235] Q_out2[1236] Q_out2[1237] Q_out2[1238] Q_out2[1239] Q_out2[1240]
+ Q_out2[1241] Q_out2[1242] Q_out2[1243] Q_out2[1244] Q_out2[1245] Q_out2[1246] Q_out2[1247] Q_out2[1248] Q_out2[1249] Q_out2[1250] Q_out2[1251]
+ Q_out2[1252] Q_out2[1253] Q_out2[1254] Q_out2[1255] Q_out2[1256] Q_out2[1257] Q_out2[1258] Q_out2[1259] Q_out2[1260] Q_out2[1261] Q_out2[1262]
+ Q_out2[1263] Q_out2[1264] Q_out2[1265] Q_out2[1266] Q_out2[1267] Q_out2[1268] Q_out2[1269] Q_out2[1270] Q_out2[1271] Q_out2[1272] Q_out2[1273]
+ Q_out2[1274] Q_out2[1275] Q_out2[1276] Q_out2[1277] Q_out2[1278] Q_out2[1279] Q_out2[1280] Q_out2[1281] Q_out2[1282] Q_out2[1283] Q_out2[1284]
+ Q_out2[1285] Q_out2[1286] Q_out2[1287] Q_out2[1288] Q_out2[1289] Q_out2[1290] Q_out2[1291] Q_out2[1292] Q_out2[1293] Q_out2[1294] Q_out2[1295]
+ Q_out2[1296] Q_out2[1297] Q_out2[1298] Q_out2[1299] Q_out2[1300] Q_out2[1301] Q_out2[1302] Q_out2[1303] Q_out2[1304] Q_out2[1305] Q_out2[1306]
+ Q_out2[1307] Q_out2[1308] Q_out2[1309] Q_out2[1310] Q_out2[1311] Q_out2[1312] Q_out2[1313] Q_out2[1314] Q_out2[1315] Q_out2[1316] Q_out2[1317]
+ Q_out2[1318] Q_out2[1319] Q_out2[1320] Q_out2[1321] Q_out2[1322] Q_out2[1323] Q_out2[1324] Q_out2[1325] Q_out2[1326] Q_out2[1327] Q_out2[1328]
+ Q_out2[1329] Q_out2[1330] Q_out2[1331] Q_out2[1332] Q_out2[1333] Q_out2[1334] Q_out2[1335] Q_out2[1336] Q_out2[1337] Q_out2[1338] Q_out2[1339]
+ Q_out2[1340] Q_out2[1341] Q_out2[1342] Q_out2[1343] Q_out2[1344] Q_out2[1345] Q_out2[1346] Q_out2[1347] Q_out2[1348] Q_out2[1349] Q_out2[1350]
+ Q_out2[1351] Q_out2[1352] Q_out2[1353] Q_out2[1354] Q_out2[1355] Q_out2[1356] Q_out2[1357] Q_out2[1358] Q_out2[1359] Q_out2[1360] Q_out2[1361]
+ Q_out2[1362] Q_out2[1363] Q_out2[1364] Q_out2[1365] Q_out2[1366] Q_out2[1367] Q_out2[1368] Q_out2[1369] Q_out2[1370] Q_out2[1371] Q_out2[1372]
+ Q_out2[1373] Q_out2[1374] Q_out2[1375] Q_out2[1376] Q_out2[1377] Q_out2[1378] Q_out2[1379] Q_out2[1380] Q_out2[1381] Q_out2[1382] Q_out2[1383]
+ Q_out2[1384] Q_out2[1385] Q_out2[1386] Q_out2[1387] Q_out2[1388] Q_out2[1389] Q_out2[1390] Q_out2[1391] Q_out2[1392] Q_out2[1393] Q_out2[1394]
+ Q_out2[1395] Q_out2[1396] Q_out2[1397] Q_out2[1398] Q_out2[1399] Q_out2[1400] Q_out2[1401] Q_out2[1402] Q_out2[1403] Q_out2[1404] Q_out2[1405]
+ Q_out2[1406] Q_out2[1407] Q_out2[1408] Q_out2[1409] Q_out2[1410] Q_out2[1411] Q_out2[1412] Q_out2[1413] Q_out2[1414] Q_out2[1415] Q_out2[1416]
+ Q_out2[1417] Q_out2[1418] Q_out2[1419] Q_out2[1420] Q_out2[1421] Q_out2[1422] Q_out2[1423] Q_out2[1424] Q_out2[1425] Q_out2[1426] Q_out2[1427]
+ Q_out2[1428] Q_out2[1429] Q_out2[1430] Q_out2[1431] Q_out2[1432] Q_out2[1433] Q_out2[1434] Q_out2[1435] Q_out2[1436] Q_out2[1437] Q_out2[1438]
+ Q_out2[1439] Q_out2[1440] Q_out2[1441] Q_out2[1442] Q_out2[1443] Q_out2[1444] Q_out2[1445] Q_out2[1446] Q_out2[1447] Q_out2[1448] Q_out2[1449]
+ Q_out2[1450] Q_out2[1451] Q_out2[1452] Q_out2[1453] Q_out2[1454] Q_out2[1455] Q_out2[1456] Q_out2[1457] Q_out2[1458] Q_out2[1459] Q_out2[1460]
+ Q_out2[1461] Q_out2[1462] Q_out2[1463] Q_out2[1464] Q_out2[1465] Q_out2[1466] Q_out2[1467] Q_out2[1468] Q_out2[1469] Q_out2[1470] Q_out2[1471]
+ Q_out2[1472] Q_out2[1473] Q_out2[1474] Q_out2[1475] Q_out2[1476] Q_out2[1477] Q_out2[1478] Q_out2[1479] Q_out2[1480] Q_out2[1481] Q_out2[1482]
+ Q_out2[1483] Q_out2[1484] Q_out2[1485] Q_out2[1486] Q_out2[1487] Q_out2[1488] Q_out2[1489] Q_out2[1490] Q_out2[1491] Q_out2[1492] Q_out2[1493]
+ Q_out2[1494] Q_out2[1495] Q_out2[1496] Q_out2[1497] Q_out2[1498] Q_out2[1499] Q_out2[1500] Q_out2[1501] Q_out2[1502] Q_out2[1503] Q_out2[1504]
+ Q_out2[1505] Q_out2[1506] Q_out2[1507] Q_out2[1508] Q_out2[1509] Q_out2[1510] Q_out2[1511] Q_out2[1512] Q_out2[1513] Q_out2[1514] Q_out2[1515]
+ Q_out2[1516] Q_out2[1517] Q_out2[1518] Q_out2[1519] Q_out2[1520] Q_out2[1521] Q_out2[1522] Q_out2[1523] Q_out2[1524] Q_out2[1525] Q_out2[1526]
+ Q_out2[1527] Q_out2[1528] Q_out2[1529] Q_out2[1530] Q_out2[1531] Q_out2[1532] Q_out2[1533] Q_out2[1534] Q_out2[1535] Q_out2[1536] Q_out2[1537]
+ Q_out2[1538] Q_out2[1539] Q_out2[1540] Q_out2[1541] Q_out2[1542] Q_out2[1543] Q_out2[1544] Q_out2[1545] Q_out2[1546] Q_out2[1547] Q_out2[1548]
+ Q_out2[1549] Q_out2[1550] Q_out2[1551] Q_out2[1552] Q_out2[1553] Q_out2[1554] Q_out2[1555] Q_out2[1556] Q_out2[1557] Q_out2[1558] Q_out2[1559]
+ Q_out2[1560] Q_out2[1561] Q_out2[1562] Q_out2[1563] Q_out2[1564] Q_out2[1565] Q_out2[1566] Q_out2[1567] Q_out2[1568] Q_out2[1569] Q_out2[1570]
+ Q_out2[1571] Q_out2[1572] Q_out2[1573] Q_out2[1574] Q_out2[1575] Q_out2[1576] Q_out2[1577] Q_out2[1578] Q_out2[1579] Q_out2[1580] Q_out2[1581]
+ Q_out2[1582] Q_out2[1583] Q_out2[1584] Q_out2[1585] Q_out2[1586] Q_out2[1587] Q_out2[1588] Q_out2[1589] Q_out2[1590] Q_out2[1591] Q_out2[1592]
+ Q_out2[1593] Q_out2[1594] Q_out2[1595] Q_out2[1596] Q_out2[1597] Q_out2[1598] Q_out2[1599] Q_out2[1600] Q_out2[1601] Q_out2[1602] Q_out2[1603]
+ Q_out2[1604] Q_out2[1605] Q_out2[1606] Q_out2[1607] Q_out2[1608] Q_out2[1609] Q_out2[1610] Q_out2[1611] Q_out2[1612] Q_out2[1613] Q_out2[1614]
+ Q_out2[1615] Q_out2[1616] Q_out2[1617] Q_out2[1618] Q_out2[1619] Q_out2[1620] Q_out2[1621] Q_out2[1622] Q_out2[1623] Q_out2[1624] Q_out2[1625]
+ Q_out2[1626] Q_out2[1627] Q_out2[1628] Q_out2[1629] Q_out2[1630] Q_out2[1631] Q_out2[1632] D_out_row2[1] D_out_row2[2] D_out_row2[3]
+ D_out_row2[4] D_out_row2[5] D_out_row2[6] D_out_row2[7] D_out_row2[8] D_out_row2[9] D_out_row2[10] D_out_row2[11] D_out_row2[12] D_out_row2[13]
+ D_out_row2[14] D_out_row2[15] D_out_row2[16] D_out_row2[17] D_out_row2[18] D_out_row2[19] D_out_row2[20] D_out_row2[21] D_out_row2[22]
+ D_out_row2[23] D_out_row2[24] D_out_row2[25] D_out_row2[26] D_out_row2[27] D_out_row2[28] D_out_row2[29] D_out_row2[30] D_out_row2[31]
+ D_out_row2[32] D_out_row2[33] D_out_row2[34] D_out_row2[35] D_out_row2[36] D_out_row2[37] D_out_row2[38] D_out_row2[39] D_out_row2[40]
+ D_out_row2[41] D_out_row2[42] D_out_row2[43] D_out_row2[44] D_out_row2[45] D_out_row2[46] D_out_row2[47] D_out_row2[48] D_out_row2[49]
+ D_out_row2[50] D_out_row2[51] D_out_row2[52] D_out_row2[53] D_out_row2[54] D_out_row2[55] D_out_row2[56] D_out_row2[57] D_out_row2[58]
+ D_out_row2[59] D_out_row2[60] D_out_row2[61] D_out_row2[62] D_out_row2[63] D_out_row2[64] D_out_row2[65] D_out_row2[66] D_out_row2[67]
+ swmatrix_68_by_25
x3 enable_in net3 VDDd VSSd PHI_CLK_buf
* noconn Q_out2[1:1632]
* noconn D_out_row2[1:67],D_out
* noconn Q_out[1:1488]
* noconn D_out_row[1:61],D_out1
.ends

* expanding   symbol:  switch_matrix_gf180mcu_9t5v0/swmatrix_62_by_25/swmatrix_62_by_25.sym # of pins=11
** sym_path: /foss/designs/libs/switch_matrix_gf180mcu_9t5v0/swmatrix_62_by_25/swmatrix_62_by_25.sym
** sch_path: /foss/designs/libs/switch_matrix_gf180mcu_9t5v0/swmatrix_62_by_25/swmatrix_62_by_25.sch
.subckt swmatrix_62_by_25 D_in D_out PHI_1 PHI_2 BUS[1] BUS[2] BUS[3] BUS[4] BUS[5] BUS[6] BUS[7] BUS[8] BUS[9] BUS[10] BUS[11]
+ BUS[12] BUS[13] BUS[14] BUS[15] BUS[16] BUS[17] BUS[18] BUS[19] BUS[20] BUS[21] BUS[22] BUS[23] BUS[24] BUS[25] PIN[1] PIN[2] PIN[3]
+ PIN[4] PIN[5] PIN[6] PIN[7] PIN[8] PIN[9] PIN[10] PIN[11] PIN[12] PIN[13] PIN[14] PIN[15] PIN[16] PIN[17] PIN[18] PIN[19] PIN[20]
+ PIN[21] PIN[22] PIN[23] PIN[24] PIN[25] PIN[26] PIN[27] PIN[28] PIN[29] PIN[30] PIN[31] PIN[32] PIN[33] PIN[34] PIN[35] PIN[36] PIN[37]
+ PIN[38] PIN[39] PIN[40] PIN[41] PIN[42] PIN[43] PIN[44] PIN[45] PIN[46] PIN[47] PIN[48] PIN[49] PIN[50] PIN[51] PIN[52] PIN[53] PIN[54]
+ PIN[55] PIN[56] PIN[57] PIN[58] PIN[59] PIN[60] PIN[61] PIN[62] VDDd VSSd enable Q_out[1] Q_out[2] Q_out[3] Q_out[4] Q_out[5] Q_out[6]
+ Q_out[7] Q_out[8] Q_out[9] Q_out[10] Q_out[11] Q_out[12] Q_out[13] Q_out[14] Q_out[15] Q_out[16] Q_out[17] Q_out[18] Q_out[19] Q_out[20]
+ Q_out[21] Q_out[22] Q_out[23] Q_out[24] Q_out[25] Q_out[26] Q_out[27] Q_out[28] Q_out[29] Q_out[30] Q_out[31] Q_out[32] Q_out[33] Q_out[34]
+ Q_out[35] Q_out[36] Q_out[37] Q_out[38] Q_out[39] Q_out[40] Q_out[41] Q_out[42] Q_out[43] Q_out[44] Q_out[45] Q_out[46] Q_out[47] Q_out[48]
+ Q_out[49] Q_out[50] Q_out[51] Q_out[52] Q_out[53] Q_out[54] Q_out[55] Q_out[56] Q_out[57] Q_out[58] Q_out[59] Q_out[60] Q_out[61] Q_out[62]
+ Q_out[63] Q_out[64] Q_out[65] Q_out[66] Q_out[67] Q_out[68] Q_out[69] Q_out[70] Q_out[71] Q_out[72] Q_out[73] Q_out[74] Q_out[75] Q_out[76]
+ Q_out[77] Q_out[78] Q_out[79] Q_out[80] Q_out[81] Q_out[82] Q_out[83] Q_out[84] Q_out[85] Q_out[86] Q_out[87] Q_out[88] Q_out[89] Q_out[90]
+ Q_out[91] Q_out[92] Q_out[93] Q_out[94] Q_out[95] Q_out[96] Q_out[97] Q_out[98] Q_out[99] Q_out[100] Q_out[101] Q_out[102] Q_out[103]
+ Q_out[104] Q_out[105] Q_out[106] Q_out[107] Q_out[108] Q_out[109] Q_out[110] Q_out[111] Q_out[112] Q_out[113] Q_out[114] Q_out[115]
+ Q_out[116] Q_out[117] Q_out[118] Q_out[119] Q_out[120] Q_out[121] Q_out[122] Q_out[123] Q_out[124] Q_out[125] Q_out[126] Q_out[127]
+ Q_out[128] Q_out[129] Q_out[130] Q_out[131] Q_out[132] Q_out[133] Q_out[134] Q_out[135] Q_out[136] Q_out[137] Q_out[138] Q_out[139]
+ Q_out[140] Q_out[141] Q_out[142] Q_out[143] Q_out[144] Q_out[145] Q_out[146] Q_out[147] Q_out[148] Q_out[149] Q_out[150] Q_out[151]
+ Q_out[152] Q_out[153] Q_out[154] Q_out[155] Q_out[156] Q_out[157] Q_out[158] Q_out[159] Q_out[160] Q_out[161] Q_out[162] Q_out[163]
+ Q_out[164] Q_out[165] Q_out[166] Q_out[167] Q_out[168] Q_out[169] Q_out[170] Q_out[171] Q_out[172] Q_out[173] Q_out[174] Q_out[175]
+ Q_out[176] Q_out[177] Q_out[178] Q_out[179] Q_out[180] Q_out[181] Q_out[182] Q_out[183] Q_out[184] Q_out[185] Q_out[186] Q_out[187]
+ Q_out[188] Q_out[189] Q_out[190] Q_out[191] Q_out[192] Q_out[193] Q_out[194] Q_out[195] Q_out[196] Q_out[197] Q_out[198] Q_out[199]
+ Q_out[200] Q_out[201] Q_out[202] Q_out[203] Q_out[204] Q_out[205] Q_out[206] Q_out[207] Q_out[208] Q_out[209] Q_out[210] Q_out[211]
+ Q_out[212] Q_out[213] Q_out[214] Q_out[215] Q_out[216] Q_out[217] Q_out[218] Q_out[219] Q_out[220] Q_out[221] Q_out[222] Q_out[223]
+ Q_out[224] Q_out[225] Q_out[226] Q_out[227] Q_out[228] Q_out[229] Q_out[230] Q_out[231] Q_out[232] Q_out[233] Q_out[234] Q_out[235]
+ Q_out[236] Q_out[237] Q_out[238] Q_out[239] Q_out[240] Q_out[241] Q_out[242] Q_out[243] Q_out[244] Q_out[245] Q_out[246] Q_out[247]
+ Q_out[248] Q_out[249] Q_out[250] Q_out[251] Q_out[252] Q_out[253] Q_out[254] Q_out[255] Q_out[256] Q_out[257] Q_out[258] Q_out[259]
+ Q_out[260] Q_out[261] Q_out[262] Q_out[263] Q_out[264] Q_out[265] Q_out[266] Q_out[267] Q_out[268] Q_out[269] Q_out[270] Q_out[271]
+ Q_out[272] Q_out[273] Q_out[274] Q_out[275] Q_out[276] Q_out[277] Q_out[278] Q_out[279] Q_out[280] Q_out[281] Q_out[282] Q_out[283]
+ Q_out[284] Q_out[285] Q_out[286] Q_out[287] Q_out[288] Q_out[289] Q_out[290] Q_out[291] Q_out[292] Q_out[293] Q_out[294] Q_out[295]
+ Q_out[296] Q_out[297] Q_out[298] Q_out[299] Q_out[300] Q_out[301] Q_out[302] Q_out[303] Q_out[304] Q_out[305] Q_out[306] Q_out[307]
+ Q_out[308] Q_out[309] Q_out[310] Q_out[311] Q_out[312] Q_out[313] Q_out[314] Q_out[315] Q_out[316] Q_out[317] Q_out[318] Q_out[319]
+ Q_out[320] Q_out[321] Q_out[322] Q_out[323] Q_out[324] Q_out[325] Q_out[326] Q_out[327] Q_out[328] Q_out[329] Q_out[330] Q_out[331]
+ Q_out[332] Q_out[333] Q_out[334] Q_out[335] Q_out[336] Q_out[337] Q_out[338] Q_out[339] Q_out[340] Q_out[341] Q_out[342] Q_out[343]
+ Q_out[344] Q_out[345] Q_out[346] Q_out[347] Q_out[348] Q_out[349] Q_out[350] Q_out[351] Q_out[352] Q_out[353] Q_out[354] Q_out[355]
+ Q_out[356] Q_out[357] Q_out[358] Q_out[359] Q_out[360] Q_out[361] Q_out[362] Q_out[363] Q_out[364] Q_out[365] Q_out[366] Q_out[367]
+ Q_out[368] Q_out[369] Q_out[370] Q_out[371] Q_out[372] Q_out[373] Q_out[374] Q_out[375] Q_out[376] Q_out[377] Q_out[378] Q_out[379]
+ Q_out[380] Q_out[381] Q_out[382] Q_out[383] Q_out[384] Q_out[385] Q_out[386] Q_out[387] Q_out[388] Q_out[389] Q_out[390] Q_out[391]
+ Q_out[392] Q_out[393] Q_out[394] Q_out[395] Q_out[396] Q_out[397] Q_out[398] Q_out[399] Q_out[400] Q_out[401] Q_out[402] Q_out[403]
+ Q_out[404] Q_out[405] Q_out[406] Q_out[407] Q_out[408] Q_out[409] Q_out[410] Q_out[411] Q_out[412] Q_out[413] Q_out[414] Q_out[415]
+ Q_out[416] Q_out[417] Q_out[418] Q_out[419] Q_out[420] Q_out[421] Q_out[422] Q_out[423] Q_out[424] Q_out[425] Q_out[426] Q_out[427]
+ Q_out[428] Q_out[429] Q_out[430] Q_out[431] Q_out[432] Q_out[433] Q_out[434] Q_out[435] Q_out[436] Q_out[437] Q_out[438] Q_out[439]
+ Q_out[440] Q_out[441] Q_out[442] Q_out[443] Q_out[444] Q_out[445] Q_out[446] Q_out[447] Q_out[448] Q_out[449] Q_out[450] Q_out[451]
+ Q_out[452] Q_out[453] Q_out[454] Q_out[455] Q_out[456] Q_out[457] Q_out[458] Q_out[459] Q_out[460] Q_out[461] Q_out[462] Q_out[463]
+ Q_out[464] Q_out[465] Q_out[466] Q_out[467] Q_out[468] Q_out[469] Q_out[470] Q_out[471] Q_out[472] Q_out[473] Q_out[474] Q_out[475]
+ Q_out[476] Q_out[477] Q_out[478] Q_out[479] Q_out[480] Q_out[481] Q_out[482] Q_out[483] Q_out[484] Q_out[485] Q_out[486] Q_out[487]
+ Q_out[488] Q_out[489] Q_out[490] Q_out[491] Q_out[492] Q_out[493] Q_out[494] Q_out[495] Q_out[496] Q_out[497] Q_out[498] Q_out[499]
+ Q_out[500] Q_out[501] Q_out[502] Q_out[503] Q_out[504] Q_out[505] Q_out[506] Q_out[507] Q_out[508] Q_out[509] Q_out[510] Q_out[511]
+ Q_out[512] Q_out[513] Q_out[514] Q_out[515] Q_out[516] Q_out[517] Q_out[518] Q_out[519] Q_out[520] Q_out[521] Q_out[522] Q_out[523]
+ Q_out[524] Q_out[525] Q_out[526] Q_out[527] Q_out[528] Q_out[529] Q_out[530] Q_out[531] Q_out[532] Q_out[533] Q_out[534] Q_out[535]
+ Q_out[536] Q_out[537] Q_out[538] Q_out[539] Q_out[540] Q_out[541] Q_out[542] Q_out[543] Q_out[544] Q_out[545] Q_out[546] Q_out[547]
+ Q_out[548] Q_out[549] Q_out[550] Q_out[551] Q_out[552] Q_out[553] Q_out[554] Q_out[555] Q_out[556] Q_out[557] Q_out[558] Q_out[559]
+ Q_out[560] Q_out[561] Q_out[562] Q_out[563] Q_out[564] Q_out[565] Q_out[566] Q_out[567] Q_out[568] Q_out[569] Q_out[570] Q_out[571]
+ Q_out[572] Q_out[573] Q_out[574] Q_out[575] Q_out[576] Q_out[577] Q_out[578] Q_out[579] Q_out[580] Q_out[581] Q_out[582] Q_out[583]
+ Q_out[584] Q_out[585] Q_out[586] Q_out[587] Q_out[588] Q_out[589] Q_out[590] Q_out[591] Q_out[592] Q_out[593] Q_out[594] Q_out[595]
+ Q_out[596] Q_out[597] Q_out[598] Q_out[599] Q_out[600] Q_out[601] Q_out[602] Q_out[603] Q_out[604] Q_out[605] Q_out[606] Q_out[607]
+ Q_out[608] Q_out[609] Q_out[610] Q_out[611] Q_out[612] Q_out[613] Q_out[614] Q_out[615] Q_out[616] Q_out[617] Q_out[618] Q_out[619]
+ Q_out[620] Q_out[621] Q_out[622] Q_out[623] Q_out[624] Q_out[625] Q_out[626] Q_out[627] Q_out[628] Q_out[629] Q_out[630] Q_out[631]
+ Q_out[632] Q_out[633] Q_out[634] Q_out[635] Q_out[636] Q_out[637] Q_out[638] Q_out[639] Q_out[640] Q_out[641] Q_out[642] Q_out[643]
+ Q_out[644] Q_out[645] Q_out[646] Q_out[647] Q_out[648] Q_out[649] Q_out[650] Q_out[651] Q_out[652] Q_out[653] Q_out[654] Q_out[655]
+ Q_out[656] Q_out[657] Q_out[658] Q_out[659] Q_out[660] Q_out[661] Q_out[662] Q_out[663] Q_out[664] Q_out[665] Q_out[666] Q_out[667]
+ Q_out[668] Q_out[669] Q_out[670] Q_out[671] Q_out[672] Q_out[673] Q_out[674] Q_out[675] Q_out[676] Q_out[677] Q_out[678] Q_out[679]
+ Q_out[680] Q_out[681] Q_out[682] Q_out[683] Q_out[684] Q_out[685] Q_out[686] Q_out[687] Q_out[688] Q_out[689] Q_out[690] Q_out[691]
+ Q_out[692] Q_out[693] Q_out[694] Q_out[695] Q_out[696] Q_out[697] Q_out[698] Q_out[699] Q_out[700] Q_out[701] Q_out[702] Q_out[703]
+ Q_out[704] Q_out[705] Q_out[706] Q_out[707] Q_out[708] Q_out[709] Q_out[710] Q_out[711] Q_out[712] Q_out[713] Q_out[714] Q_out[715]
+ Q_out[716] Q_out[717] Q_out[718] Q_out[719] Q_out[720] Q_out[721] Q_out[722] Q_out[723] Q_out[724] Q_out[725] Q_out[726] Q_out[727]
+ Q_out[728] Q_out[729] Q_out[730] Q_out[731] Q_out[732] Q_out[733] Q_out[734] Q_out[735] Q_out[736] Q_out[737] Q_out[738] Q_out[739]
+ Q_out[740] Q_out[741] Q_out[742] Q_out[743] Q_out[744] Q_out[745] Q_out[746] Q_out[747] Q_out[748] Q_out[749] Q_out[750] Q_out[751]
+ Q_out[752] Q_out[753] Q_out[754] Q_out[755] Q_out[756] Q_out[757] Q_out[758] Q_out[759] Q_out[760] Q_out[761] Q_out[762] Q_out[763]
+ Q_out[764] Q_out[765] Q_out[766] Q_out[767] Q_out[768] Q_out[769] Q_out[770] Q_out[771] Q_out[772] Q_out[773] Q_out[774] Q_out[775]
+ Q_out[776] Q_out[777] Q_out[778] Q_out[779] Q_out[780] Q_out[781] Q_out[782] Q_out[783] Q_out[784] Q_out[785] Q_out[786] Q_out[787]
+ Q_out[788] Q_out[789] Q_out[790] Q_out[791] Q_out[792] Q_out[793] Q_out[794] Q_out[795] Q_out[796] Q_out[797] Q_out[798] Q_out[799]
+ Q_out[800] Q_out[801] Q_out[802] Q_out[803] Q_out[804] Q_out[805] Q_out[806] Q_out[807] Q_out[808] Q_out[809] Q_out[810] Q_out[811]
+ Q_out[812] Q_out[813] Q_out[814] Q_out[815] Q_out[816] Q_out[817] Q_out[818] Q_out[819] Q_out[820] Q_out[821] Q_out[822] Q_out[823]
+ Q_out[824] Q_out[825] Q_out[826] Q_out[827] Q_out[828] Q_out[829] Q_out[830] Q_out[831] Q_out[832] Q_out[833] Q_out[834] Q_out[835]
+ Q_out[836] Q_out[837] Q_out[838] Q_out[839] Q_out[840] Q_out[841] Q_out[842] Q_out[843] Q_out[844] Q_out[845] Q_out[846] Q_out[847]
+ Q_out[848] Q_out[849] Q_out[850] Q_out[851] Q_out[852] Q_out[853] Q_out[854] Q_out[855] Q_out[856] Q_out[857] Q_out[858] Q_out[859]
+ Q_out[860] Q_out[861] Q_out[862] Q_out[863] Q_out[864] Q_out[865] Q_out[866] Q_out[867] Q_out[868] Q_out[869] Q_out[870] Q_out[871]
+ Q_out[872] Q_out[873] Q_out[874] Q_out[875] Q_out[876] Q_out[877] Q_out[878] Q_out[879] Q_out[880] Q_out[881] Q_out[882] Q_out[883]
+ Q_out[884] Q_out[885] Q_out[886] Q_out[887] Q_out[888] Q_out[889] Q_out[890] Q_out[891] Q_out[892] Q_out[893] Q_out[894] Q_out[895]
+ Q_out[896] Q_out[897] Q_out[898] Q_out[899] Q_out[900] Q_out[901] Q_out[902] Q_out[903] Q_out[904] Q_out[905] Q_out[906] Q_out[907]
+ Q_out[908] Q_out[909] Q_out[910] Q_out[911] Q_out[912] Q_out[913] Q_out[914] Q_out[915] Q_out[916] Q_out[917] Q_out[918] Q_out[919]
+ Q_out[920] Q_out[921] Q_out[922] Q_out[923] Q_out[924] Q_out[925] Q_out[926] Q_out[927] Q_out[928] Q_out[929] Q_out[930] Q_out[931]
+ Q_out[932] Q_out[933] Q_out[934] Q_out[935] Q_out[936] Q_out[937] Q_out[938] Q_out[939] Q_out[940] Q_out[941] Q_out[942] Q_out[943]
+ Q_out[944] Q_out[945] Q_out[946] Q_out[947] Q_out[948] Q_out[949] Q_out[950] Q_out[951] Q_out[952] Q_out[953] Q_out[954] Q_out[955]
+ Q_out[956] Q_out[957] Q_out[958] Q_out[959] Q_out[960] Q_out[961] Q_out[962] Q_out[963] Q_out[964] Q_out[965] Q_out[966] Q_out[967]
+ Q_out[968] Q_out[969] Q_out[970] Q_out[971] Q_out[972] Q_out[973] Q_out[974] Q_out[975] Q_out[976] Q_out[977] Q_out[978] Q_out[979]
+ Q_out[980] Q_out[981] Q_out[982] Q_out[983] Q_out[984] Q_out[985] Q_out[986] Q_out[987] Q_out[988] Q_out[989] Q_out[990] Q_out[991]
+ Q_out[992] Q_out[993] Q_out[994] Q_out[995] Q_out[996] Q_out[997] Q_out[998] Q_out[999] Q_out[1000] Q_out[1001] Q_out[1002] Q_out[1003]
+ Q_out[1004] Q_out[1005] Q_out[1006] Q_out[1007] Q_out[1008] Q_out[1009] Q_out[1010] Q_out[1011] Q_out[1012] Q_out[1013] Q_out[1014]
+ Q_out[1015] Q_out[1016] Q_out[1017] Q_out[1018] Q_out[1019] Q_out[1020] Q_out[1021] Q_out[1022] Q_out[1023] Q_out[1024] Q_out[1025]
+ Q_out[1026] Q_out[1027] Q_out[1028] Q_out[1029] Q_out[1030] Q_out[1031] Q_out[1032] Q_out[1033] Q_out[1034] Q_out[1035] Q_out[1036]
+ Q_out[1037] Q_out[1038] Q_out[1039] Q_out[1040] Q_out[1041] Q_out[1042] Q_out[1043] Q_out[1044] Q_out[1045] Q_out[1046] Q_out[1047]
+ Q_out[1048] Q_out[1049] Q_out[1050] Q_out[1051] Q_out[1052] Q_out[1053] Q_out[1054] Q_out[1055] Q_out[1056] Q_out[1057] Q_out[1058]
+ Q_out[1059] Q_out[1060] Q_out[1061] Q_out[1062] Q_out[1063] Q_out[1064] Q_out[1065] Q_out[1066] Q_out[1067] Q_out[1068] Q_out[1069]
+ Q_out[1070] Q_out[1071] Q_out[1072] Q_out[1073] Q_out[1074] Q_out[1075] Q_out[1076] Q_out[1077] Q_out[1078] Q_out[1079] Q_out[1080]
+ Q_out[1081] Q_out[1082] Q_out[1083] Q_out[1084] Q_out[1085] Q_out[1086] Q_out[1087] Q_out[1088] Q_out[1089] Q_out[1090] Q_out[1091]
+ Q_out[1092] Q_out[1093] Q_out[1094] Q_out[1095] Q_out[1096] Q_out[1097] Q_out[1098] Q_out[1099] Q_out[1100] Q_out[1101] Q_out[1102]
+ Q_out[1103] Q_out[1104] Q_out[1105] Q_out[1106] Q_out[1107] Q_out[1108] Q_out[1109] Q_out[1110] Q_out[1111] Q_out[1112] Q_out[1113]
+ Q_out[1114] Q_out[1115] Q_out[1116] Q_out[1117] Q_out[1118] Q_out[1119] Q_out[1120] Q_out[1121] Q_out[1122] Q_out[1123] Q_out[1124]
+ Q_out[1125] Q_out[1126] Q_out[1127] Q_out[1128] Q_out[1129] Q_out[1130] Q_out[1131] Q_out[1132] Q_out[1133] Q_out[1134] Q_out[1135]
+ Q_out[1136] Q_out[1137] Q_out[1138] Q_out[1139] Q_out[1140] Q_out[1141] Q_out[1142] Q_out[1143] Q_out[1144] Q_out[1145] Q_out[1146]
+ Q_out[1147] Q_out[1148] Q_out[1149] Q_out[1150] Q_out[1151] Q_out[1152] Q_out[1153] Q_out[1154] Q_out[1155] Q_out[1156] Q_out[1157]
+ Q_out[1158] Q_out[1159] Q_out[1160] Q_out[1161] Q_out[1162] Q_out[1163] Q_out[1164] Q_out[1165] Q_out[1166] Q_out[1167] Q_out[1168]
+ Q_out[1169] Q_out[1170] Q_out[1171] Q_out[1172] Q_out[1173] Q_out[1174] Q_out[1175] Q_out[1176] Q_out[1177] Q_out[1178] Q_out[1179]
+ Q_out[1180] Q_out[1181] Q_out[1182] Q_out[1183] Q_out[1184] Q_out[1185] Q_out[1186] Q_out[1187] Q_out[1188] Q_out[1189] Q_out[1190]
+ Q_out[1191] Q_out[1192] Q_out[1193] Q_out[1194] Q_out[1195] Q_out[1196] Q_out[1197] Q_out[1198] Q_out[1199] Q_out[1200] Q_out[1201]
+ Q_out[1202] Q_out[1203] Q_out[1204] Q_out[1205] Q_out[1206] Q_out[1207] Q_out[1208] Q_out[1209] Q_out[1210] Q_out[1211] Q_out[1212]
+ Q_out[1213] Q_out[1214] Q_out[1215] Q_out[1216] Q_out[1217] Q_out[1218] Q_out[1219] Q_out[1220] Q_out[1221] Q_out[1222] Q_out[1223]
+ Q_out[1224] Q_out[1225] Q_out[1226] Q_out[1227] Q_out[1228] Q_out[1229] Q_out[1230] Q_out[1231] Q_out[1232] Q_out[1233] Q_out[1234]
+ Q_out[1235] Q_out[1236] Q_out[1237] Q_out[1238] Q_out[1239] Q_out[1240] Q_out[1241] Q_out[1242] Q_out[1243] Q_out[1244] Q_out[1245]
+ Q_out[1246] Q_out[1247] Q_out[1248] Q_out[1249] Q_out[1250] Q_out[1251] Q_out[1252] Q_out[1253] Q_out[1254] Q_out[1255] Q_out[1256]
+ Q_out[1257] Q_out[1258] Q_out[1259] Q_out[1260] Q_out[1261] Q_out[1262] Q_out[1263] Q_out[1264] Q_out[1265] Q_out[1266] Q_out[1267]
+ Q_out[1268] Q_out[1269] Q_out[1270] Q_out[1271] Q_out[1272] Q_out[1273] Q_out[1274] Q_out[1275] Q_out[1276] Q_out[1277] Q_out[1278]
+ Q_out[1279] Q_out[1280] Q_out[1281] Q_out[1282] Q_out[1283] Q_out[1284] Q_out[1285] Q_out[1286] Q_out[1287] Q_out[1288] Q_out[1289]
+ Q_out[1290] Q_out[1291] Q_out[1292] Q_out[1293] Q_out[1294] Q_out[1295] Q_out[1296] Q_out[1297] Q_out[1298] Q_out[1299] Q_out[1300]
+ Q_out[1301] Q_out[1302] Q_out[1303] Q_out[1304] Q_out[1305] Q_out[1306] Q_out[1307] Q_out[1308] Q_out[1309] Q_out[1310] Q_out[1311]
+ Q_out[1312] Q_out[1313] Q_out[1314] Q_out[1315] Q_out[1316] Q_out[1317] Q_out[1318] Q_out[1319] Q_out[1320] Q_out[1321] Q_out[1322]
+ Q_out[1323] Q_out[1324] Q_out[1325] Q_out[1326] Q_out[1327] Q_out[1328] Q_out[1329] Q_out[1330] Q_out[1331] Q_out[1332] Q_out[1333]
+ Q_out[1334] Q_out[1335] Q_out[1336] Q_out[1337] Q_out[1338] Q_out[1339] Q_out[1340] Q_out[1341] Q_out[1342] Q_out[1343] Q_out[1344]
+ Q_out[1345] Q_out[1346] Q_out[1347] Q_out[1348] Q_out[1349] Q_out[1350] Q_out[1351] Q_out[1352] Q_out[1353] Q_out[1354] Q_out[1355]
+ Q_out[1356] Q_out[1357] Q_out[1358] Q_out[1359] Q_out[1360] Q_out[1361] Q_out[1362] Q_out[1363] Q_out[1364] Q_out[1365] Q_out[1366]
+ Q_out[1367] Q_out[1368] Q_out[1369] Q_out[1370] Q_out[1371] Q_out[1372] Q_out[1373] Q_out[1374] Q_out[1375] Q_out[1376] Q_out[1377]
+ Q_out[1378] Q_out[1379] Q_out[1380] Q_out[1381] Q_out[1382] Q_out[1383] Q_out[1384] Q_out[1385] Q_out[1386] Q_out[1387] Q_out[1388]
+ Q_out[1389] Q_out[1390] Q_out[1391] Q_out[1392] Q_out[1393] Q_out[1394] Q_out[1395] Q_out[1396] Q_out[1397] Q_out[1398] Q_out[1399]
+ Q_out[1400] Q_out[1401] Q_out[1402] Q_out[1403] Q_out[1404] Q_out[1405] Q_out[1406] Q_out[1407] Q_out[1408] Q_out[1409] Q_out[1410]
+ Q_out[1411] Q_out[1412] Q_out[1413] Q_out[1414] Q_out[1415] Q_out[1416] Q_out[1417] Q_out[1418] Q_out[1419] Q_out[1420] Q_out[1421]
+ Q_out[1422] Q_out[1423] Q_out[1424] Q_out[1425] Q_out[1426] Q_out[1427] Q_out[1428] Q_out[1429] Q_out[1430] Q_out[1431] Q_out[1432]
+ Q_out[1433] Q_out[1434] Q_out[1435] Q_out[1436] Q_out[1437] Q_out[1438] Q_out[1439] Q_out[1440] Q_out[1441] Q_out[1442] Q_out[1443]
+ Q_out[1444] Q_out[1445] Q_out[1446] Q_out[1447] Q_out[1448] Q_out[1449] Q_out[1450] Q_out[1451] Q_out[1452] Q_out[1453] Q_out[1454]
+ Q_out[1455] Q_out[1456] Q_out[1457] Q_out[1458] Q_out[1459] Q_out[1460] Q_out[1461] Q_out[1462] Q_out[1463] Q_out[1464] Q_out[1465]
+ Q_out[1466] Q_out[1467] Q_out[1468] Q_out[1469] Q_out[1470] Q_out[1471] Q_out[1472] Q_out[1473] Q_out[1474] Q_out[1475] Q_out[1476]
+ Q_out[1477] Q_out[1478] Q_out[1479] Q_out[1480] Q_out[1481] Q_out[1482] Q_out[1483] Q_out[1484] Q_out[1485] Q_out[1486] Q_out[1487]
+ Q_out[1488] D_out_row[1] D_out_row[2] D_out_row[3] D_out_row[4] D_out_row[5] D_out_row[6] D_out_row[7] D_out_row[8] D_out_row[9]
+ D_out_row[10] D_out_row[11] D_out_row[12] D_out_row[13] D_out_row[14] D_out_row[15] D_out_row[16] D_out_row[17] D_out_row[18] D_out_row[19]
+ D_out_row[20] D_out_row[21] D_out_row[22] D_out_row[23] D_out_row[24] D_out_row[25] D_out_row[26] D_out_row[27] D_out_row[28] D_out_row[29]
+ D_out_row[30] D_out_row[31] D_out_row[32] D_out_row[33] D_out_row[34] D_out_row[35] D_out_row[36] D_out_row[37] D_out_row[38] D_out_row[39]
+ D_out_row[40] D_out_row[41] D_out_row[42] D_out_row[43] D_out_row[44] D_out_row[45] D_out_row[46] D_out_row[47] D_out_row[48] D_out_row[49]
+ D_out_row[50] D_out_row[51] D_out_row[52] D_out_row[53] D_out_row[54] D_out_row[55] D_out_row[56] D_out_row[57] D_out_row[58] D_out_row[59]
+ D_out_row[60] D_out_row[61]
*.PININFO PIN[1:62]:B BUS[1:25]:B PHI_1:I PHI_2:I D_in:I Q_out[1:1488]:B VDDd:B VSSd:B enable:I D_out:B D_out_row[1:61]:B
xswmatrix_row[1] D_in D_out_row[1] PHI_1 PHI_2 BUS[1] BUS[2] BUS[3] BUS[4] BUS[5] BUS[6] BUS[7] BUS[8] BUS[9] BUS[10] BUS[11]
+ BUS[12] BUS[13] BUS[14] BUS[15] BUS[16] BUS[17] BUS[18] BUS[19] BUS[20] BUS[21] BUS[22] BUS[23] BUS[24] BUS[25] PIN[1] VDDd VSSd enable
+ Q_out[1] Q_out[2] Q_out[3] Q_out[4] Q_out[5] Q_out[6] Q_out[7] Q_out[8] Q_out[9] Q_out[10] Q_out[11] Q_out[12] Q_out[13] Q_out[14]
+ Q_out[15] Q_out[16] Q_out[17] Q_out[18] Q_out[19] Q_out[20] Q_out[21] Q_out[22] Q_out[23] Q_out[24] swmatrix_row_25_w_clkbuf
xswmatrix_row[2] D_out_row[1] D_out_row[2] PHI_1 PHI_2 BUS[1] BUS[2] BUS[3] BUS[4] BUS[5] BUS[6] BUS[7] BUS[8] BUS[9] BUS[10]
+ BUS[11] BUS[12] BUS[13] BUS[14] BUS[15] BUS[16] BUS[17] BUS[18] BUS[19] BUS[20] BUS[21] BUS[22] BUS[23] BUS[24] BUS[25] PIN[2] VDDd VSSd
+ enable Q_out[25] Q_out[26] Q_out[27] Q_out[28] Q_out[29] Q_out[30] Q_out[31] Q_out[32] Q_out[33] Q_out[34] Q_out[35] Q_out[36] Q_out[37]
+ Q_out[38] Q_out[39] Q_out[40] Q_out[41] Q_out[42] Q_out[43] Q_out[44] Q_out[45] Q_out[46] Q_out[47] Q_out[48] swmatrix_row_25_w_clkbuf
xswmatrix_row[3] D_out_row[2] D_out_row[3] PHI_1 PHI_2 BUS[1] BUS[2] BUS[3] BUS[4] BUS[5] BUS[6] BUS[7] BUS[8] BUS[9] BUS[10]
+ BUS[11] BUS[12] BUS[13] BUS[14] BUS[15] BUS[16] BUS[17] BUS[18] BUS[19] BUS[20] BUS[21] BUS[22] BUS[23] BUS[24] BUS[25] PIN[3] VDDd VSSd
+ enable Q_out[49] Q_out[50] Q_out[51] Q_out[52] Q_out[53] Q_out[54] Q_out[55] Q_out[56] Q_out[57] Q_out[58] Q_out[59] Q_out[60] Q_out[61]
+ Q_out[62] Q_out[63] Q_out[64] Q_out[65] Q_out[66] Q_out[67] Q_out[68] Q_out[69] Q_out[70] Q_out[71] Q_out[72] swmatrix_row_25_w_clkbuf
xswmatrix_row[4] D_out_row[3] D_out_row[4] PHI_1 PHI_2 BUS[1] BUS[2] BUS[3] BUS[4] BUS[5] BUS[6] BUS[7] BUS[8] BUS[9] BUS[10]
+ BUS[11] BUS[12] BUS[13] BUS[14] BUS[15] BUS[16] BUS[17] BUS[18] BUS[19] BUS[20] BUS[21] BUS[22] BUS[23] BUS[24] BUS[25] PIN[4] VDDd VSSd
+ enable Q_out[73] Q_out[74] Q_out[75] Q_out[76] Q_out[77] Q_out[78] Q_out[79] Q_out[80] Q_out[81] Q_out[82] Q_out[83] Q_out[84] Q_out[85]
+ Q_out[86] Q_out[87] Q_out[88] Q_out[89] Q_out[90] Q_out[91] Q_out[92] Q_out[93] Q_out[94] Q_out[95] Q_out[96] swmatrix_row_25_w_clkbuf
xswmatrix_row[5] D_out_row[4] D_out_row[5] PHI_1 PHI_2 BUS[1] BUS[2] BUS[3] BUS[4] BUS[5] BUS[6] BUS[7] BUS[8] BUS[9] BUS[10]
+ BUS[11] BUS[12] BUS[13] BUS[14] BUS[15] BUS[16] BUS[17] BUS[18] BUS[19] BUS[20] BUS[21] BUS[22] BUS[23] BUS[24] BUS[25] PIN[5] VDDd VSSd
+ enable Q_out[97] Q_out[98] Q_out[99] Q_out[100] Q_out[101] Q_out[102] Q_out[103] Q_out[104] Q_out[105] Q_out[106] Q_out[107] Q_out[108]
+ Q_out[109] Q_out[110] Q_out[111] Q_out[112] Q_out[113] Q_out[114] Q_out[115] Q_out[116] Q_out[117] Q_out[118] Q_out[119] Q_out[120]
+ swmatrix_row_25_w_clkbuf
xswmatrix_row[6] D_out_row[5] D_out_row[6] PHI_1 PHI_2 BUS[1] BUS[2] BUS[3] BUS[4] BUS[5] BUS[6] BUS[7] BUS[8] BUS[9] BUS[10]
+ BUS[11] BUS[12] BUS[13] BUS[14] BUS[15] BUS[16] BUS[17] BUS[18] BUS[19] BUS[20] BUS[21] BUS[22] BUS[23] BUS[24] BUS[25] PIN[6] VDDd VSSd
+ enable Q_out[121] Q_out[122] Q_out[123] Q_out[124] Q_out[125] Q_out[126] Q_out[127] Q_out[128] Q_out[129] Q_out[130] Q_out[131]
+ Q_out[132] Q_out[133] Q_out[134] Q_out[135] Q_out[136] Q_out[137] Q_out[138] Q_out[139] Q_out[140] Q_out[141] Q_out[142] Q_out[143]
+ Q_out[144] swmatrix_row_25_w_clkbuf
xswmatrix_row[7] D_out_row[6] D_out_row[7] PHI_1 PHI_2 BUS[1] BUS[2] BUS[3] BUS[4] BUS[5] BUS[6] BUS[7] BUS[8] BUS[9] BUS[10]
+ BUS[11] BUS[12] BUS[13] BUS[14] BUS[15] BUS[16] BUS[17] BUS[18] BUS[19] BUS[20] BUS[21] BUS[22] BUS[23] BUS[24] BUS[25] PIN[7] VDDd VSSd
+ enable Q_out[145] Q_out[146] Q_out[147] Q_out[148] Q_out[149] Q_out[150] Q_out[151] Q_out[152] Q_out[153] Q_out[154] Q_out[155]
+ Q_out[156] Q_out[157] Q_out[158] Q_out[159] Q_out[160] Q_out[161] Q_out[162] Q_out[163] Q_out[164] Q_out[165] Q_out[166] Q_out[167]
+ Q_out[168] swmatrix_row_25_w_clkbuf
xswmatrix_row[8] D_out_row[7] D_out_row[8] PHI_1 PHI_2 BUS[1] BUS[2] BUS[3] BUS[4] BUS[5] BUS[6] BUS[7] BUS[8] BUS[9] BUS[10]
+ BUS[11] BUS[12] BUS[13] BUS[14] BUS[15] BUS[16] BUS[17] BUS[18] BUS[19] BUS[20] BUS[21] BUS[22] BUS[23] BUS[24] BUS[25] PIN[8] VDDd VSSd
+ enable Q_out[169] Q_out[170] Q_out[171] Q_out[172] Q_out[173] Q_out[174] Q_out[175] Q_out[176] Q_out[177] Q_out[178] Q_out[179]
+ Q_out[180] Q_out[181] Q_out[182] Q_out[183] Q_out[184] Q_out[185] Q_out[186] Q_out[187] Q_out[188] Q_out[189] Q_out[190] Q_out[191]
+ Q_out[192] swmatrix_row_25_w_clkbuf
xswmatrix_row[9] D_out_row[8] D_out_row[9] PHI_1 PHI_2 BUS[1] BUS[2] BUS[3] BUS[4] BUS[5] BUS[6] BUS[7] BUS[8] BUS[9] BUS[10]
+ BUS[11] BUS[12] BUS[13] BUS[14] BUS[15] BUS[16] BUS[17] BUS[18] BUS[19] BUS[20] BUS[21] BUS[22] BUS[23] BUS[24] BUS[25] PIN[9] VDDd VSSd
+ enable Q_out[193] Q_out[194] Q_out[195] Q_out[196] Q_out[197] Q_out[198] Q_out[199] Q_out[200] Q_out[201] Q_out[202] Q_out[203]
+ Q_out[204] Q_out[205] Q_out[206] Q_out[207] Q_out[208] Q_out[209] Q_out[210] Q_out[211] Q_out[212] Q_out[213] Q_out[214] Q_out[215]
+ Q_out[216] swmatrix_row_25_w_clkbuf
xswmatrix_row[10] D_out_row[9] D_out_row[10] PHI_1 PHI_2 BUS[1] BUS[2] BUS[3] BUS[4] BUS[5] BUS[6] BUS[7] BUS[8] BUS[9] BUS[10]
+ BUS[11] BUS[12] BUS[13] BUS[14] BUS[15] BUS[16] BUS[17] BUS[18] BUS[19] BUS[20] BUS[21] BUS[22] BUS[23] BUS[24] BUS[25] PIN[10] VDDd VSSd
+ enable Q_out[217] Q_out[218] Q_out[219] Q_out[220] Q_out[221] Q_out[222] Q_out[223] Q_out[224] Q_out[225] Q_out[226] Q_out[227]
+ Q_out[228] Q_out[229] Q_out[230] Q_out[231] Q_out[232] Q_out[233] Q_out[234] Q_out[235] Q_out[236] Q_out[237] Q_out[238] Q_out[239]
+ Q_out[240] swmatrix_row_25_w_clkbuf
xswmatrix_row[11] D_out_row[10] D_out_row[11] PHI_1 PHI_2 BUS[1] BUS[2] BUS[3] BUS[4] BUS[5] BUS[6] BUS[7] BUS[8] BUS[9] BUS[10]
+ BUS[11] BUS[12] BUS[13] BUS[14] BUS[15] BUS[16] BUS[17] BUS[18] BUS[19] BUS[20] BUS[21] BUS[22] BUS[23] BUS[24] BUS[25] PIN[11] VDDd VSSd
+ enable Q_out[241] Q_out[242] Q_out[243] Q_out[244] Q_out[245] Q_out[246] Q_out[247] Q_out[248] Q_out[249] Q_out[250] Q_out[251]
+ Q_out[252] Q_out[253] Q_out[254] Q_out[255] Q_out[256] Q_out[257] Q_out[258] Q_out[259] Q_out[260] Q_out[261] Q_out[262] Q_out[263]
+ Q_out[264] swmatrix_row_25_w_clkbuf
xswmatrix_row[12] D_out_row[11] D_out_row[12] PHI_1 PHI_2 BUS[1] BUS[2] BUS[3] BUS[4] BUS[5] BUS[6] BUS[7] BUS[8] BUS[9] BUS[10]
+ BUS[11] BUS[12] BUS[13] BUS[14] BUS[15] BUS[16] BUS[17] BUS[18] BUS[19] BUS[20] BUS[21] BUS[22] BUS[23] BUS[24] BUS[25] PIN[12] VDDd VSSd
+ enable Q_out[265] Q_out[266] Q_out[267] Q_out[268] Q_out[269] Q_out[270] Q_out[271] Q_out[272] Q_out[273] Q_out[274] Q_out[275]
+ Q_out[276] Q_out[277] Q_out[278] Q_out[279] Q_out[280] Q_out[281] Q_out[282] Q_out[283] Q_out[284] Q_out[285] Q_out[286] Q_out[287]
+ Q_out[288] swmatrix_row_25_w_clkbuf
xswmatrix_row[13] D_out_row[12] D_out_row[13] PHI_1 PHI_2 BUS[1] BUS[2] BUS[3] BUS[4] BUS[5] BUS[6] BUS[7] BUS[8] BUS[9] BUS[10]
+ BUS[11] BUS[12] BUS[13] BUS[14] BUS[15] BUS[16] BUS[17] BUS[18] BUS[19] BUS[20] BUS[21] BUS[22] BUS[23] BUS[24] BUS[25] PIN[13] VDDd VSSd
+ enable Q_out[289] Q_out[290] Q_out[291] Q_out[292] Q_out[293] Q_out[294] Q_out[295] Q_out[296] Q_out[297] Q_out[298] Q_out[299]
+ Q_out[300] Q_out[301] Q_out[302] Q_out[303] Q_out[304] Q_out[305] Q_out[306] Q_out[307] Q_out[308] Q_out[309] Q_out[310] Q_out[311]
+ Q_out[312] swmatrix_row_25_w_clkbuf
xswmatrix_row[14] D_out_row[13] D_out_row[14] PHI_1 PHI_2 BUS[1] BUS[2] BUS[3] BUS[4] BUS[5] BUS[6] BUS[7] BUS[8] BUS[9] BUS[10]
+ BUS[11] BUS[12] BUS[13] BUS[14] BUS[15] BUS[16] BUS[17] BUS[18] BUS[19] BUS[20] BUS[21] BUS[22] BUS[23] BUS[24] BUS[25] PIN[14] VDDd VSSd
+ enable Q_out[313] Q_out[314] Q_out[315] Q_out[316] Q_out[317] Q_out[318] Q_out[319] Q_out[320] Q_out[321] Q_out[322] Q_out[323]
+ Q_out[324] Q_out[325] Q_out[326] Q_out[327] Q_out[328] Q_out[329] Q_out[330] Q_out[331] Q_out[332] Q_out[333] Q_out[334] Q_out[335]
+ Q_out[336] swmatrix_row_25_w_clkbuf
xswmatrix_row[15] D_out_row[14] D_out_row[15] PHI_1 PHI_2 BUS[1] BUS[2] BUS[3] BUS[4] BUS[5] BUS[6] BUS[7] BUS[8] BUS[9] BUS[10]
+ BUS[11] BUS[12] BUS[13] BUS[14] BUS[15] BUS[16] BUS[17] BUS[18] BUS[19] BUS[20] BUS[21] BUS[22] BUS[23] BUS[24] BUS[25] PIN[15] VDDd VSSd
+ enable Q_out[337] Q_out[338] Q_out[339] Q_out[340] Q_out[341] Q_out[342] Q_out[343] Q_out[344] Q_out[345] Q_out[346] Q_out[347]
+ Q_out[348] Q_out[349] Q_out[350] Q_out[351] Q_out[352] Q_out[353] Q_out[354] Q_out[355] Q_out[356] Q_out[357] Q_out[358] Q_out[359]
+ Q_out[360] swmatrix_row_25_w_clkbuf
xswmatrix_row[16] D_out_row[15] D_out_row[16] PHI_1 PHI_2 BUS[1] BUS[2] BUS[3] BUS[4] BUS[5] BUS[6] BUS[7] BUS[8] BUS[9] BUS[10]
+ BUS[11] BUS[12] BUS[13] BUS[14] BUS[15] BUS[16] BUS[17] BUS[18] BUS[19] BUS[20] BUS[21] BUS[22] BUS[23] BUS[24] BUS[25] PIN[16] VDDd VSSd
+ enable Q_out[361] Q_out[362] Q_out[363] Q_out[364] Q_out[365] Q_out[366] Q_out[367] Q_out[368] Q_out[369] Q_out[370] Q_out[371]
+ Q_out[372] Q_out[373] Q_out[374] Q_out[375] Q_out[376] Q_out[377] Q_out[378] Q_out[379] Q_out[380] Q_out[381] Q_out[382] Q_out[383]
+ Q_out[384] swmatrix_row_25_w_clkbuf
xswmatrix_row[17] D_out_row[16] D_out_row[17] PHI_1 PHI_2 BUS[1] BUS[2] BUS[3] BUS[4] BUS[5] BUS[6] BUS[7] BUS[8] BUS[9] BUS[10]
+ BUS[11] BUS[12] BUS[13] BUS[14] BUS[15] BUS[16] BUS[17] BUS[18] BUS[19] BUS[20] BUS[21] BUS[22] BUS[23] BUS[24] BUS[25] PIN[17] VDDd VSSd
+ enable Q_out[385] Q_out[386] Q_out[387] Q_out[388] Q_out[389] Q_out[390] Q_out[391] Q_out[392] Q_out[393] Q_out[394] Q_out[395]
+ Q_out[396] Q_out[397] Q_out[398] Q_out[399] Q_out[400] Q_out[401] Q_out[402] Q_out[403] Q_out[404] Q_out[405] Q_out[406] Q_out[407]
+ Q_out[408] swmatrix_row_25_w_clkbuf
xswmatrix_row[18] D_out_row[17] D_out_row[18] PHI_1 PHI_2 BUS[1] BUS[2] BUS[3] BUS[4] BUS[5] BUS[6] BUS[7] BUS[8] BUS[9] BUS[10]
+ BUS[11] BUS[12] BUS[13] BUS[14] BUS[15] BUS[16] BUS[17] BUS[18] BUS[19] BUS[20] BUS[21] BUS[22] BUS[23] BUS[24] BUS[25] PIN[18] VDDd VSSd
+ enable Q_out[409] Q_out[410] Q_out[411] Q_out[412] Q_out[413] Q_out[414] Q_out[415] Q_out[416] Q_out[417] Q_out[418] Q_out[419]
+ Q_out[420] Q_out[421] Q_out[422] Q_out[423] Q_out[424] Q_out[425] Q_out[426] Q_out[427] Q_out[428] Q_out[429] Q_out[430] Q_out[431]
+ Q_out[432] swmatrix_row_25_w_clkbuf
xswmatrix_row[19] D_out_row[18] D_out_row[19] PHI_1 PHI_2 BUS[1] BUS[2] BUS[3] BUS[4] BUS[5] BUS[6] BUS[7] BUS[8] BUS[9] BUS[10]
+ BUS[11] BUS[12] BUS[13] BUS[14] BUS[15] BUS[16] BUS[17] BUS[18] BUS[19] BUS[20] BUS[21] BUS[22] BUS[23] BUS[24] BUS[25] PIN[19] VDDd VSSd
+ enable Q_out[433] Q_out[434] Q_out[435] Q_out[436] Q_out[437] Q_out[438] Q_out[439] Q_out[440] Q_out[441] Q_out[442] Q_out[443]
+ Q_out[444] Q_out[445] Q_out[446] Q_out[447] Q_out[448] Q_out[449] Q_out[450] Q_out[451] Q_out[452] Q_out[453] Q_out[454] Q_out[455]
+ Q_out[456] swmatrix_row_25_w_clkbuf
xswmatrix_row[20] D_out_row[19] D_out_row[20] PHI_1 PHI_2 BUS[1] BUS[2] BUS[3] BUS[4] BUS[5] BUS[6] BUS[7] BUS[8] BUS[9] BUS[10]
+ BUS[11] BUS[12] BUS[13] BUS[14] BUS[15] BUS[16] BUS[17] BUS[18] BUS[19] BUS[20] BUS[21] BUS[22] BUS[23] BUS[24] BUS[25] PIN[20] VDDd VSSd
+ enable Q_out[457] Q_out[458] Q_out[459] Q_out[460] Q_out[461] Q_out[462] Q_out[463] Q_out[464] Q_out[465] Q_out[466] Q_out[467]
+ Q_out[468] Q_out[469] Q_out[470] Q_out[471] Q_out[472] Q_out[473] Q_out[474] Q_out[475] Q_out[476] Q_out[477] Q_out[478] Q_out[479]
+ Q_out[480] swmatrix_row_25_w_clkbuf
xswmatrix_row[21] D_out_row[20] D_out_row[21] PHI_1 PHI_2 BUS[1] BUS[2] BUS[3] BUS[4] BUS[5] BUS[6] BUS[7] BUS[8] BUS[9] BUS[10]
+ BUS[11] BUS[12] BUS[13] BUS[14] BUS[15] BUS[16] BUS[17] BUS[18] BUS[19] BUS[20] BUS[21] BUS[22] BUS[23] BUS[24] BUS[25] PIN[21] VDDd VSSd
+ enable Q_out[481] Q_out[482] Q_out[483] Q_out[484] Q_out[485] Q_out[486] Q_out[487] Q_out[488] Q_out[489] Q_out[490] Q_out[491]
+ Q_out[492] Q_out[493] Q_out[494] Q_out[495] Q_out[496] Q_out[497] Q_out[498] Q_out[499] Q_out[500] Q_out[501] Q_out[502] Q_out[503]
+ Q_out[504] swmatrix_row_25_w_clkbuf
xswmatrix_row[22] D_out_row[21] D_out_row[22] PHI_1 PHI_2 BUS[1] BUS[2] BUS[3] BUS[4] BUS[5] BUS[6] BUS[7] BUS[8] BUS[9] BUS[10]
+ BUS[11] BUS[12] BUS[13] BUS[14] BUS[15] BUS[16] BUS[17] BUS[18] BUS[19] BUS[20] BUS[21] BUS[22] BUS[23] BUS[24] BUS[25] PIN[22] VDDd VSSd
+ enable Q_out[505] Q_out[506] Q_out[507] Q_out[508] Q_out[509] Q_out[510] Q_out[511] Q_out[512] Q_out[513] Q_out[514] Q_out[515]
+ Q_out[516] Q_out[517] Q_out[518] Q_out[519] Q_out[520] Q_out[521] Q_out[522] Q_out[523] Q_out[524] Q_out[525] Q_out[526] Q_out[527]
+ Q_out[528] swmatrix_row_25_w_clkbuf
xswmatrix_row[23] D_out_row[22] D_out_row[23] PHI_1 PHI_2 BUS[1] BUS[2] BUS[3] BUS[4] BUS[5] BUS[6] BUS[7] BUS[8] BUS[9] BUS[10]
+ BUS[11] BUS[12] BUS[13] BUS[14] BUS[15] BUS[16] BUS[17] BUS[18] BUS[19] BUS[20] BUS[21] BUS[22] BUS[23] BUS[24] BUS[25] PIN[23] VDDd VSSd
+ enable Q_out[529] Q_out[530] Q_out[531] Q_out[532] Q_out[533] Q_out[534] Q_out[535] Q_out[536] Q_out[537] Q_out[538] Q_out[539]
+ Q_out[540] Q_out[541] Q_out[542] Q_out[543] Q_out[544] Q_out[545] Q_out[546] Q_out[547] Q_out[548] Q_out[549] Q_out[550] Q_out[551]
+ Q_out[552] swmatrix_row_25_w_clkbuf
xswmatrix_row[24] D_out_row[23] D_out_row[24] PHI_1 PHI_2 BUS[1] BUS[2] BUS[3] BUS[4] BUS[5] BUS[6] BUS[7] BUS[8] BUS[9] BUS[10]
+ BUS[11] BUS[12] BUS[13] BUS[14] BUS[15] BUS[16] BUS[17] BUS[18] BUS[19] BUS[20] BUS[21] BUS[22] BUS[23] BUS[24] BUS[25] PIN[24] VDDd VSSd
+ enable Q_out[553] Q_out[554] Q_out[555] Q_out[556] Q_out[557] Q_out[558] Q_out[559] Q_out[560] Q_out[561] Q_out[562] Q_out[563]
+ Q_out[564] Q_out[565] Q_out[566] Q_out[567] Q_out[568] Q_out[569] Q_out[570] Q_out[571] Q_out[572] Q_out[573] Q_out[574] Q_out[575]
+ Q_out[576] swmatrix_row_25_w_clkbuf
xswmatrix_row[25] D_out_row[24] D_out_row[25] PHI_1 PHI_2 BUS[1] BUS[2] BUS[3] BUS[4] BUS[5] BUS[6] BUS[7] BUS[8] BUS[9] BUS[10]
+ BUS[11] BUS[12] BUS[13] BUS[14] BUS[15] BUS[16] BUS[17] BUS[18] BUS[19] BUS[20] BUS[21] BUS[22] BUS[23] BUS[24] BUS[25] PIN[25] VDDd VSSd
+ enable Q_out[577] Q_out[578] Q_out[579] Q_out[580] Q_out[581] Q_out[582] Q_out[583] Q_out[584] Q_out[585] Q_out[586] Q_out[587]
+ Q_out[588] Q_out[589] Q_out[590] Q_out[591] Q_out[592] Q_out[593] Q_out[594] Q_out[595] Q_out[596] Q_out[597] Q_out[598] Q_out[599]
+ Q_out[600] swmatrix_row_25_w_clkbuf
xswmatrix_row[26] D_out_row[25] D_out_row[26] PHI_1 PHI_2 BUS[1] BUS[2] BUS[3] BUS[4] BUS[5] BUS[6] BUS[7] BUS[8] BUS[9] BUS[10]
+ BUS[11] BUS[12] BUS[13] BUS[14] BUS[15] BUS[16] BUS[17] BUS[18] BUS[19] BUS[20] BUS[21] BUS[22] BUS[23] BUS[24] BUS[25] PIN[26] VDDd VSSd
+ enable Q_out[601] Q_out[602] Q_out[603] Q_out[604] Q_out[605] Q_out[606] Q_out[607] Q_out[608] Q_out[609] Q_out[610] Q_out[611]
+ Q_out[612] Q_out[613] Q_out[614] Q_out[615] Q_out[616] Q_out[617] Q_out[618] Q_out[619] Q_out[620] Q_out[621] Q_out[622] Q_out[623]
+ Q_out[624] swmatrix_row_25_w_clkbuf
xswmatrix_row[27] D_out_row[26] D_out_row[27] PHI_1 PHI_2 BUS[1] BUS[2] BUS[3] BUS[4] BUS[5] BUS[6] BUS[7] BUS[8] BUS[9] BUS[10]
+ BUS[11] BUS[12] BUS[13] BUS[14] BUS[15] BUS[16] BUS[17] BUS[18] BUS[19] BUS[20] BUS[21] BUS[22] BUS[23] BUS[24] BUS[25] PIN[27] VDDd VSSd
+ enable Q_out[625] Q_out[626] Q_out[627] Q_out[628] Q_out[629] Q_out[630] Q_out[631] Q_out[632] Q_out[633] Q_out[634] Q_out[635]
+ Q_out[636] Q_out[637] Q_out[638] Q_out[639] Q_out[640] Q_out[641] Q_out[642] Q_out[643] Q_out[644] Q_out[645] Q_out[646] Q_out[647]
+ Q_out[648] swmatrix_row_25_w_clkbuf
xswmatrix_row[28] D_out_row[27] D_out_row[28] PHI_1 PHI_2 BUS[1] BUS[2] BUS[3] BUS[4] BUS[5] BUS[6] BUS[7] BUS[8] BUS[9] BUS[10]
+ BUS[11] BUS[12] BUS[13] BUS[14] BUS[15] BUS[16] BUS[17] BUS[18] BUS[19] BUS[20] BUS[21] BUS[22] BUS[23] BUS[24] BUS[25] PIN[28] VDDd VSSd
+ enable Q_out[649] Q_out[650] Q_out[651] Q_out[652] Q_out[653] Q_out[654] Q_out[655] Q_out[656] Q_out[657] Q_out[658] Q_out[659]
+ Q_out[660] Q_out[661] Q_out[662] Q_out[663] Q_out[664] Q_out[665] Q_out[666] Q_out[667] Q_out[668] Q_out[669] Q_out[670] Q_out[671]
+ Q_out[672] swmatrix_row_25_w_clkbuf
xswmatrix_row[29] D_out_row[28] D_out_row[29] PHI_1 PHI_2 BUS[1] BUS[2] BUS[3] BUS[4] BUS[5] BUS[6] BUS[7] BUS[8] BUS[9] BUS[10]
+ BUS[11] BUS[12] BUS[13] BUS[14] BUS[15] BUS[16] BUS[17] BUS[18] BUS[19] BUS[20] BUS[21] BUS[22] BUS[23] BUS[24] BUS[25] PIN[29] VDDd VSSd
+ enable Q_out[673] Q_out[674] Q_out[675] Q_out[676] Q_out[677] Q_out[678] Q_out[679] Q_out[680] Q_out[681] Q_out[682] Q_out[683]
+ Q_out[684] Q_out[685] Q_out[686] Q_out[687] Q_out[688] Q_out[689] Q_out[690] Q_out[691] Q_out[692] Q_out[693] Q_out[694] Q_out[695]
+ Q_out[696] swmatrix_row_25_w_clkbuf
xswmatrix_row[30] D_out_row[29] D_out_row[30] PHI_1 PHI_2 BUS[1] BUS[2] BUS[3] BUS[4] BUS[5] BUS[6] BUS[7] BUS[8] BUS[9] BUS[10]
+ BUS[11] BUS[12] BUS[13] BUS[14] BUS[15] BUS[16] BUS[17] BUS[18] BUS[19] BUS[20] BUS[21] BUS[22] BUS[23] BUS[24] BUS[25] PIN[30] VDDd VSSd
+ enable Q_out[697] Q_out[698] Q_out[699] Q_out[700] Q_out[701] Q_out[702] Q_out[703] Q_out[704] Q_out[705] Q_out[706] Q_out[707]
+ Q_out[708] Q_out[709] Q_out[710] Q_out[711] Q_out[712] Q_out[713] Q_out[714] Q_out[715] Q_out[716] Q_out[717] Q_out[718] Q_out[719]
+ Q_out[720] swmatrix_row_25_w_clkbuf
xswmatrix_row[31] D_out_row[30] D_out_row[31] PHI_1 PHI_2 BUS[1] BUS[2] BUS[3] BUS[4] BUS[5] BUS[6] BUS[7] BUS[8] BUS[9] BUS[10]
+ BUS[11] BUS[12] BUS[13] BUS[14] BUS[15] BUS[16] BUS[17] BUS[18] BUS[19] BUS[20] BUS[21] BUS[22] BUS[23] BUS[24] BUS[25] PIN[31] VDDd VSSd
+ enable Q_out[721] Q_out[722] Q_out[723] Q_out[724] Q_out[725] Q_out[726] Q_out[727] Q_out[728] Q_out[729] Q_out[730] Q_out[731]
+ Q_out[732] Q_out[733] Q_out[734] Q_out[735] Q_out[736] Q_out[737] Q_out[738] Q_out[739] Q_out[740] Q_out[741] Q_out[742] Q_out[743]
+ Q_out[744] swmatrix_row_25_w_clkbuf
xswmatrix_row[32] D_out_row[31] D_out_row[32] PHI_1 PHI_2 BUS[1] BUS[2] BUS[3] BUS[4] BUS[5] BUS[6] BUS[7] BUS[8] BUS[9] BUS[10]
+ BUS[11] BUS[12] BUS[13] BUS[14] BUS[15] BUS[16] BUS[17] BUS[18] BUS[19] BUS[20] BUS[21] BUS[22] BUS[23] BUS[24] BUS[25] PIN[32] VDDd VSSd
+ enable Q_out[745] Q_out[746] Q_out[747] Q_out[748] Q_out[749] Q_out[750] Q_out[751] Q_out[752] Q_out[753] Q_out[754] Q_out[755]
+ Q_out[756] Q_out[757] Q_out[758] Q_out[759] Q_out[760] Q_out[761] Q_out[762] Q_out[763] Q_out[764] Q_out[765] Q_out[766] Q_out[767]
+ Q_out[768] swmatrix_row_25_w_clkbuf
xswmatrix_row[33] D_out_row[32] D_out_row[33] PHI_1 PHI_2 BUS[1] BUS[2] BUS[3] BUS[4] BUS[5] BUS[6] BUS[7] BUS[8] BUS[9] BUS[10]
+ BUS[11] BUS[12] BUS[13] BUS[14] BUS[15] BUS[16] BUS[17] BUS[18] BUS[19] BUS[20] BUS[21] BUS[22] BUS[23] BUS[24] BUS[25] PIN[33] VDDd VSSd
+ enable Q_out[769] Q_out[770] Q_out[771] Q_out[772] Q_out[773] Q_out[774] Q_out[775] Q_out[776] Q_out[777] Q_out[778] Q_out[779]
+ Q_out[780] Q_out[781] Q_out[782] Q_out[783] Q_out[784] Q_out[785] Q_out[786] Q_out[787] Q_out[788] Q_out[789] Q_out[790] Q_out[791]
+ Q_out[792] swmatrix_row_25_w_clkbuf
xswmatrix_row[34] D_out_row[33] D_out_row[34] PHI_1 PHI_2 BUS[1] BUS[2] BUS[3] BUS[4] BUS[5] BUS[6] BUS[7] BUS[8] BUS[9] BUS[10]
+ BUS[11] BUS[12] BUS[13] BUS[14] BUS[15] BUS[16] BUS[17] BUS[18] BUS[19] BUS[20] BUS[21] BUS[22] BUS[23] BUS[24] BUS[25] PIN[34] VDDd VSSd
+ enable Q_out[793] Q_out[794] Q_out[795] Q_out[796] Q_out[797] Q_out[798] Q_out[799] Q_out[800] Q_out[801] Q_out[802] Q_out[803]
+ Q_out[804] Q_out[805] Q_out[806] Q_out[807] Q_out[808] Q_out[809] Q_out[810] Q_out[811] Q_out[812] Q_out[813] Q_out[814] Q_out[815]
+ Q_out[816] swmatrix_row_25_w_clkbuf
xswmatrix_row[35] D_out_row[34] D_out_row[35] PHI_1 PHI_2 BUS[1] BUS[2] BUS[3] BUS[4] BUS[5] BUS[6] BUS[7] BUS[8] BUS[9] BUS[10]
+ BUS[11] BUS[12] BUS[13] BUS[14] BUS[15] BUS[16] BUS[17] BUS[18] BUS[19] BUS[20] BUS[21] BUS[22] BUS[23] BUS[24] BUS[25] PIN[35] VDDd VSSd
+ enable Q_out[817] Q_out[818] Q_out[819] Q_out[820] Q_out[821] Q_out[822] Q_out[823] Q_out[824] Q_out[825] Q_out[826] Q_out[827]
+ Q_out[828] Q_out[829] Q_out[830] Q_out[831] Q_out[832] Q_out[833] Q_out[834] Q_out[835] Q_out[836] Q_out[837] Q_out[838] Q_out[839]
+ Q_out[840] swmatrix_row_25_w_clkbuf
xswmatrix_row[36] D_out_row[35] D_out_row[36] PHI_1 PHI_2 BUS[1] BUS[2] BUS[3] BUS[4] BUS[5] BUS[6] BUS[7] BUS[8] BUS[9] BUS[10]
+ BUS[11] BUS[12] BUS[13] BUS[14] BUS[15] BUS[16] BUS[17] BUS[18] BUS[19] BUS[20] BUS[21] BUS[22] BUS[23] BUS[24] BUS[25] PIN[36] VDDd VSSd
+ enable Q_out[841] Q_out[842] Q_out[843] Q_out[844] Q_out[845] Q_out[846] Q_out[847] Q_out[848] Q_out[849] Q_out[850] Q_out[851]
+ Q_out[852] Q_out[853] Q_out[854] Q_out[855] Q_out[856] Q_out[857] Q_out[858] Q_out[859] Q_out[860] Q_out[861] Q_out[862] Q_out[863]
+ Q_out[864] swmatrix_row_25_w_clkbuf
xswmatrix_row[37] D_out_row[36] D_out_row[37] PHI_1 PHI_2 BUS[1] BUS[2] BUS[3] BUS[4] BUS[5] BUS[6] BUS[7] BUS[8] BUS[9] BUS[10]
+ BUS[11] BUS[12] BUS[13] BUS[14] BUS[15] BUS[16] BUS[17] BUS[18] BUS[19] BUS[20] BUS[21] BUS[22] BUS[23] BUS[24] BUS[25] PIN[37] VDDd VSSd
+ enable Q_out[865] Q_out[866] Q_out[867] Q_out[868] Q_out[869] Q_out[870] Q_out[871] Q_out[872] Q_out[873] Q_out[874] Q_out[875]
+ Q_out[876] Q_out[877] Q_out[878] Q_out[879] Q_out[880] Q_out[881] Q_out[882] Q_out[883] Q_out[884] Q_out[885] Q_out[886] Q_out[887]
+ Q_out[888] swmatrix_row_25_w_clkbuf
xswmatrix_row[38] D_out_row[37] D_out_row[38] PHI_1 PHI_2 BUS[1] BUS[2] BUS[3] BUS[4] BUS[5] BUS[6] BUS[7] BUS[8] BUS[9] BUS[10]
+ BUS[11] BUS[12] BUS[13] BUS[14] BUS[15] BUS[16] BUS[17] BUS[18] BUS[19] BUS[20] BUS[21] BUS[22] BUS[23] BUS[24] BUS[25] PIN[38] VDDd VSSd
+ enable Q_out[889] Q_out[890] Q_out[891] Q_out[892] Q_out[893] Q_out[894] Q_out[895] Q_out[896] Q_out[897] Q_out[898] Q_out[899]
+ Q_out[900] Q_out[901] Q_out[902] Q_out[903] Q_out[904] Q_out[905] Q_out[906] Q_out[907] Q_out[908] Q_out[909] Q_out[910] Q_out[911]
+ Q_out[912] swmatrix_row_25_w_clkbuf
xswmatrix_row[39] D_out_row[38] D_out_row[39] PHI_1 PHI_2 BUS[1] BUS[2] BUS[3] BUS[4] BUS[5] BUS[6] BUS[7] BUS[8] BUS[9] BUS[10]
+ BUS[11] BUS[12] BUS[13] BUS[14] BUS[15] BUS[16] BUS[17] BUS[18] BUS[19] BUS[20] BUS[21] BUS[22] BUS[23] BUS[24] BUS[25] PIN[39] VDDd VSSd
+ enable Q_out[913] Q_out[914] Q_out[915] Q_out[916] Q_out[917] Q_out[918] Q_out[919] Q_out[920] Q_out[921] Q_out[922] Q_out[923]
+ Q_out[924] Q_out[925] Q_out[926] Q_out[927] Q_out[928] Q_out[929] Q_out[930] Q_out[931] Q_out[932] Q_out[933] Q_out[934] Q_out[935]
+ Q_out[936] swmatrix_row_25_w_clkbuf
xswmatrix_row[40] D_out_row[39] D_out_row[40] PHI_1 PHI_2 BUS[1] BUS[2] BUS[3] BUS[4] BUS[5] BUS[6] BUS[7] BUS[8] BUS[9] BUS[10]
+ BUS[11] BUS[12] BUS[13] BUS[14] BUS[15] BUS[16] BUS[17] BUS[18] BUS[19] BUS[20] BUS[21] BUS[22] BUS[23] BUS[24] BUS[25] PIN[40] VDDd VSSd
+ enable Q_out[937] Q_out[938] Q_out[939] Q_out[940] Q_out[941] Q_out[942] Q_out[943] Q_out[944] Q_out[945] Q_out[946] Q_out[947]
+ Q_out[948] Q_out[949] Q_out[950] Q_out[951] Q_out[952] Q_out[953] Q_out[954] Q_out[955] Q_out[956] Q_out[957] Q_out[958] Q_out[959]
+ Q_out[960] swmatrix_row_25_w_clkbuf
xswmatrix_row[41] D_out_row[40] D_out_row[41] PHI_1 PHI_2 BUS[1] BUS[2] BUS[3] BUS[4] BUS[5] BUS[6] BUS[7] BUS[8] BUS[9] BUS[10]
+ BUS[11] BUS[12] BUS[13] BUS[14] BUS[15] BUS[16] BUS[17] BUS[18] BUS[19] BUS[20] BUS[21] BUS[22] BUS[23] BUS[24] BUS[25] PIN[41] VDDd VSSd
+ enable Q_out[961] Q_out[962] Q_out[963] Q_out[964] Q_out[965] Q_out[966] Q_out[967] Q_out[968] Q_out[969] Q_out[970] Q_out[971]
+ Q_out[972] Q_out[973] Q_out[974] Q_out[975] Q_out[976] Q_out[977] Q_out[978] Q_out[979] Q_out[980] Q_out[981] Q_out[982] Q_out[983]
+ Q_out[984] swmatrix_row_25_w_clkbuf
xswmatrix_row[42] D_out_row[41] D_out_row[42] PHI_1 PHI_2 BUS[1] BUS[2] BUS[3] BUS[4] BUS[5] BUS[6] BUS[7] BUS[8] BUS[9] BUS[10]
+ BUS[11] BUS[12] BUS[13] BUS[14] BUS[15] BUS[16] BUS[17] BUS[18] BUS[19] BUS[20] BUS[21] BUS[22] BUS[23] BUS[24] BUS[25] PIN[42] VDDd VSSd
+ enable Q_out[985] Q_out[986] Q_out[987] Q_out[988] Q_out[989] Q_out[990] Q_out[991] Q_out[992] Q_out[993] Q_out[994] Q_out[995]
+ Q_out[996] Q_out[997] Q_out[998] Q_out[999] Q_out[1000] Q_out[1001] Q_out[1002] Q_out[1003] Q_out[1004] Q_out[1005] Q_out[1006] Q_out[1007]
+ Q_out[1008] swmatrix_row_25_w_clkbuf
xswmatrix_row[43] D_out_row[42] D_out_row[43] PHI_1 PHI_2 BUS[1] BUS[2] BUS[3] BUS[4] BUS[5] BUS[6] BUS[7] BUS[8] BUS[9] BUS[10]
+ BUS[11] BUS[12] BUS[13] BUS[14] BUS[15] BUS[16] BUS[17] BUS[18] BUS[19] BUS[20] BUS[21] BUS[22] BUS[23] BUS[24] BUS[25] PIN[43] VDDd VSSd
+ enable Q_out[1009] Q_out[1010] Q_out[1011] Q_out[1012] Q_out[1013] Q_out[1014] Q_out[1015] Q_out[1016] Q_out[1017] Q_out[1018]
+ Q_out[1019] Q_out[1020] Q_out[1021] Q_out[1022] Q_out[1023] Q_out[1024] Q_out[1025] Q_out[1026] Q_out[1027] Q_out[1028] Q_out[1029]
+ Q_out[1030] Q_out[1031] Q_out[1032] swmatrix_row_25_w_clkbuf
xswmatrix_row[44] D_out_row[43] D_out_row[44] PHI_1 PHI_2 BUS[1] BUS[2] BUS[3] BUS[4] BUS[5] BUS[6] BUS[7] BUS[8] BUS[9] BUS[10]
+ BUS[11] BUS[12] BUS[13] BUS[14] BUS[15] BUS[16] BUS[17] BUS[18] BUS[19] BUS[20] BUS[21] BUS[22] BUS[23] BUS[24] BUS[25] PIN[44] VDDd VSSd
+ enable Q_out[1033] Q_out[1034] Q_out[1035] Q_out[1036] Q_out[1037] Q_out[1038] Q_out[1039] Q_out[1040] Q_out[1041] Q_out[1042]
+ Q_out[1043] Q_out[1044] Q_out[1045] Q_out[1046] Q_out[1047] Q_out[1048] Q_out[1049] Q_out[1050] Q_out[1051] Q_out[1052] Q_out[1053]
+ Q_out[1054] Q_out[1055] Q_out[1056] swmatrix_row_25_w_clkbuf
xswmatrix_row[45] D_out_row[44] D_out_row[45] PHI_1 PHI_2 BUS[1] BUS[2] BUS[3] BUS[4] BUS[5] BUS[6] BUS[7] BUS[8] BUS[9] BUS[10]
+ BUS[11] BUS[12] BUS[13] BUS[14] BUS[15] BUS[16] BUS[17] BUS[18] BUS[19] BUS[20] BUS[21] BUS[22] BUS[23] BUS[24] BUS[25] PIN[45] VDDd VSSd
+ enable Q_out[1057] Q_out[1058] Q_out[1059] Q_out[1060] Q_out[1061] Q_out[1062] Q_out[1063] Q_out[1064] Q_out[1065] Q_out[1066]
+ Q_out[1067] Q_out[1068] Q_out[1069] Q_out[1070] Q_out[1071] Q_out[1072] Q_out[1073] Q_out[1074] Q_out[1075] Q_out[1076] Q_out[1077]
+ Q_out[1078] Q_out[1079] Q_out[1080] swmatrix_row_25_w_clkbuf
xswmatrix_row[46] D_out_row[45] D_out_row[46] PHI_1 PHI_2 BUS[1] BUS[2] BUS[3] BUS[4] BUS[5] BUS[6] BUS[7] BUS[8] BUS[9] BUS[10]
+ BUS[11] BUS[12] BUS[13] BUS[14] BUS[15] BUS[16] BUS[17] BUS[18] BUS[19] BUS[20] BUS[21] BUS[22] BUS[23] BUS[24] BUS[25] PIN[46] VDDd VSSd
+ enable Q_out[1081] Q_out[1082] Q_out[1083] Q_out[1084] Q_out[1085] Q_out[1086] Q_out[1087] Q_out[1088] Q_out[1089] Q_out[1090]
+ Q_out[1091] Q_out[1092] Q_out[1093] Q_out[1094] Q_out[1095] Q_out[1096] Q_out[1097] Q_out[1098] Q_out[1099] Q_out[1100] Q_out[1101]
+ Q_out[1102] Q_out[1103] Q_out[1104] swmatrix_row_25_w_clkbuf
xswmatrix_row[47] D_out_row[46] D_out_row[47] PHI_1 PHI_2 BUS[1] BUS[2] BUS[3] BUS[4] BUS[5] BUS[6] BUS[7] BUS[8] BUS[9] BUS[10]
+ BUS[11] BUS[12] BUS[13] BUS[14] BUS[15] BUS[16] BUS[17] BUS[18] BUS[19] BUS[20] BUS[21] BUS[22] BUS[23] BUS[24] BUS[25] PIN[47] VDDd VSSd
+ enable Q_out[1105] Q_out[1106] Q_out[1107] Q_out[1108] Q_out[1109] Q_out[1110] Q_out[1111] Q_out[1112] Q_out[1113] Q_out[1114]
+ Q_out[1115] Q_out[1116] Q_out[1117] Q_out[1118] Q_out[1119] Q_out[1120] Q_out[1121] Q_out[1122] Q_out[1123] Q_out[1124] Q_out[1125]
+ Q_out[1126] Q_out[1127] Q_out[1128] swmatrix_row_25_w_clkbuf
xswmatrix_row[48] D_out_row[47] D_out_row[48] PHI_1 PHI_2 BUS[1] BUS[2] BUS[3] BUS[4] BUS[5] BUS[6] BUS[7] BUS[8] BUS[9] BUS[10]
+ BUS[11] BUS[12] BUS[13] BUS[14] BUS[15] BUS[16] BUS[17] BUS[18] BUS[19] BUS[20] BUS[21] BUS[22] BUS[23] BUS[24] BUS[25] PIN[48] VDDd VSSd
+ enable Q_out[1129] Q_out[1130] Q_out[1131] Q_out[1132] Q_out[1133] Q_out[1134] Q_out[1135] Q_out[1136] Q_out[1137] Q_out[1138]
+ Q_out[1139] Q_out[1140] Q_out[1141] Q_out[1142] Q_out[1143] Q_out[1144] Q_out[1145] Q_out[1146] Q_out[1147] Q_out[1148] Q_out[1149]
+ Q_out[1150] Q_out[1151] Q_out[1152] swmatrix_row_25_w_clkbuf
xswmatrix_row[49] D_out_row[48] D_out_row[49] PHI_1 PHI_2 BUS[1] BUS[2] BUS[3] BUS[4] BUS[5] BUS[6] BUS[7] BUS[8] BUS[9] BUS[10]
+ BUS[11] BUS[12] BUS[13] BUS[14] BUS[15] BUS[16] BUS[17] BUS[18] BUS[19] BUS[20] BUS[21] BUS[22] BUS[23] BUS[24] BUS[25] PIN[49] VDDd VSSd
+ enable Q_out[1153] Q_out[1154] Q_out[1155] Q_out[1156] Q_out[1157] Q_out[1158] Q_out[1159] Q_out[1160] Q_out[1161] Q_out[1162]
+ Q_out[1163] Q_out[1164] Q_out[1165] Q_out[1166] Q_out[1167] Q_out[1168] Q_out[1169] Q_out[1170] Q_out[1171] Q_out[1172] Q_out[1173]
+ Q_out[1174] Q_out[1175] Q_out[1176] swmatrix_row_25_w_clkbuf
xswmatrix_row[50] D_out_row[49] D_out_row[50] PHI_1 PHI_2 BUS[1] BUS[2] BUS[3] BUS[4] BUS[5] BUS[6] BUS[7] BUS[8] BUS[9] BUS[10]
+ BUS[11] BUS[12] BUS[13] BUS[14] BUS[15] BUS[16] BUS[17] BUS[18] BUS[19] BUS[20] BUS[21] BUS[22] BUS[23] BUS[24] BUS[25] PIN[50] VDDd VSSd
+ enable Q_out[1177] Q_out[1178] Q_out[1179] Q_out[1180] Q_out[1181] Q_out[1182] Q_out[1183] Q_out[1184] Q_out[1185] Q_out[1186]
+ Q_out[1187] Q_out[1188] Q_out[1189] Q_out[1190] Q_out[1191] Q_out[1192] Q_out[1193] Q_out[1194] Q_out[1195] Q_out[1196] Q_out[1197]
+ Q_out[1198] Q_out[1199] Q_out[1200] swmatrix_row_25_w_clkbuf
xswmatrix_row[51] D_out_row[50] D_out_row[51] PHI_1 PHI_2 BUS[1] BUS[2] BUS[3] BUS[4] BUS[5] BUS[6] BUS[7] BUS[8] BUS[9] BUS[10]
+ BUS[11] BUS[12] BUS[13] BUS[14] BUS[15] BUS[16] BUS[17] BUS[18] BUS[19] BUS[20] BUS[21] BUS[22] BUS[23] BUS[24] BUS[25] PIN[51] VDDd VSSd
+ enable Q_out[1201] Q_out[1202] Q_out[1203] Q_out[1204] Q_out[1205] Q_out[1206] Q_out[1207] Q_out[1208] Q_out[1209] Q_out[1210]
+ Q_out[1211] Q_out[1212] Q_out[1213] Q_out[1214] Q_out[1215] Q_out[1216] Q_out[1217] Q_out[1218] Q_out[1219] Q_out[1220] Q_out[1221]
+ Q_out[1222] Q_out[1223] Q_out[1224] swmatrix_row_25_w_clkbuf
xswmatrix_row[52] D_out_row[51] D_out_row[52] PHI_1 PHI_2 BUS[1] BUS[2] BUS[3] BUS[4] BUS[5] BUS[6] BUS[7] BUS[8] BUS[9] BUS[10]
+ BUS[11] BUS[12] BUS[13] BUS[14] BUS[15] BUS[16] BUS[17] BUS[18] BUS[19] BUS[20] BUS[21] BUS[22] BUS[23] BUS[24] BUS[25] PIN[52] VDDd VSSd
+ enable Q_out[1225] Q_out[1226] Q_out[1227] Q_out[1228] Q_out[1229] Q_out[1230] Q_out[1231] Q_out[1232] Q_out[1233] Q_out[1234]
+ Q_out[1235] Q_out[1236] Q_out[1237] Q_out[1238] Q_out[1239] Q_out[1240] Q_out[1241] Q_out[1242] Q_out[1243] Q_out[1244] Q_out[1245]
+ Q_out[1246] Q_out[1247] Q_out[1248] swmatrix_row_25_w_clkbuf
xswmatrix_row[53] D_out_row[52] D_out_row[53] PHI_1 PHI_2 BUS[1] BUS[2] BUS[3] BUS[4] BUS[5] BUS[6] BUS[7] BUS[8] BUS[9] BUS[10]
+ BUS[11] BUS[12] BUS[13] BUS[14] BUS[15] BUS[16] BUS[17] BUS[18] BUS[19] BUS[20] BUS[21] BUS[22] BUS[23] BUS[24] BUS[25] PIN[53] VDDd VSSd
+ enable Q_out[1249] Q_out[1250] Q_out[1251] Q_out[1252] Q_out[1253] Q_out[1254] Q_out[1255] Q_out[1256] Q_out[1257] Q_out[1258]
+ Q_out[1259] Q_out[1260] Q_out[1261] Q_out[1262] Q_out[1263] Q_out[1264] Q_out[1265] Q_out[1266] Q_out[1267] Q_out[1268] Q_out[1269]
+ Q_out[1270] Q_out[1271] Q_out[1272] swmatrix_row_25_w_clkbuf
xswmatrix_row[54] D_out_row[53] D_out_row[54] PHI_1 PHI_2 BUS[1] BUS[2] BUS[3] BUS[4] BUS[5] BUS[6] BUS[7] BUS[8] BUS[9] BUS[10]
+ BUS[11] BUS[12] BUS[13] BUS[14] BUS[15] BUS[16] BUS[17] BUS[18] BUS[19] BUS[20] BUS[21] BUS[22] BUS[23] BUS[24] BUS[25] PIN[54] VDDd VSSd
+ enable Q_out[1273] Q_out[1274] Q_out[1275] Q_out[1276] Q_out[1277] Q_out[1278] Q_out[1279] Q_out[1280] Q_out[1281] Q_out[1282]
+ Q_out[1283] Q_out[1284] Q_out[1285] Q_out[1286] Q_out[1287] Q_out[1288] Q_out[1289] Q_out[1290] Q_out[1291] Q_out[1292] Q_out[1293]
+ Q_out[1294] Q_out[1295] Q_out[1296] swmatrix_row_25_w_clkbuf
xswmatrix_row[55] D_out_row[54] D_out_row[55] PHI_1 PHI_2 BUS[1] BUS[2] BUS[3] BUS[4] BUS[5] BUS[6] BUS[7] BUS[8] BUS[9] BUS[10]
+ BUS[11] BUS[12] BUS[13] BUS[14] BUS[15] BUS[16] BUS[17] BUS[18] BUS[19] BUS[20] BUS[21] BUS[22] BUS[23] BUS[24] BUS[25] PIN[55] VDDd VSSd
+ enable Q_out[1297] Q_out[1298] Q_out[1299] Q_out[1300] Q_out[1301] Q_out[1302] Q_out[1303] Q_out[1304] Q_out[1305] Q_out[1306]
+ Q_out[1307] Q_out[1308] Q_out[1309] Q_out[1310] Q_out[1311] Q_out[1312] Q_out[1313] Q_out[1314] Q_out[1315] Q_out[1316] Q_out[1317]
+ Q_out[1318] Q_out[1319] Q_out[1320] swmatrix_row_25_w_clkbuf
xswmatrix_row[56] D_out_row[55] D_out_row[56] PHI_1 PHI_2 BUS[1] BUS[2] BUS[3] BUS[4] BUS[5] BUS[6] BUS[7] BUS[8] BUS[9] BUS[10]
+ BUS[11] BUS[12] BUS[13] BUS[14] BUS[15] BUS[16] BUS[17] BUS[18] BUS[19] BUS[20] BUS[21] BUS[22] BUS[23] BUS[24] BUS[25] PIN[56] VDDd VSSd
+ enable Q_out[1321] Q_out[1322] Q_out[1323] Q_out[1324] Q_out[1325] Q_out[1326] Q_out[1327] Q_out[1328] Q_out[1329] Q_out[1330]
+ Q_out[1331] Q_out[1332] Q_out[1333] Q_out[1334] Q_out[1335] Q_out[1336] Q_out[1337] Q_out[1338] Q_out[1339] Q_out[1340] Q_out[1341]
+ Q_out[1342] Q_out[1343] Q_out[1344] swmatrix_row_25_w_clkbuf
xswmatrix_row[57] D_out_row[56] D_out_row[57] PHI_1 PHI_2 BUS[1] BUS[2] BUS[3] BUS[4] BUS[5] BUS[6] BUS[7] BUS[8] BUS[9] BUS[10]
+ BUS[11] BUS[12] BUS[13] BUS[14] BUS[15] BUS[16] BUS[17] BUS[18] BUS[19] BUS[20] BUS[21] BUS[22] BUS[23] BUS[24] BUS[25] PIN[57] VDDd VSSd
+ enable Q_out[1345] Q_out[1346] Q_out[1347] Q_out[1348] Q_out[1349] Q_out[1350] Q_out[1351] Q_out[1352] Q_out[1353] Q_out[1354]
+ Q_out[1355] Q_out[1356] Q_out[1357] Q_out[1358] Q_out[1359] Q_out[1360] Q_out[1361] Q_out[1362] Q_out[1363] Q_out[1364] Q_out[1365]
+ Q_out[1366] Q_out[1367] Q_out[1368] swmatrix_row_25_w_clkbuf
xswmatrix_row[58] D_out_row[57] D_out_row[58] PHI_1 PHI_2 BUS[1] BUS[2] BUS[3] BUS[4] BUS[5] BUS[6] BUS[7] BUS[8] BUS[9] BUS[10]
+ BUS[11] BUS[12] BUS[13] BUS[14] BUS[15] BUS[16] BUS[17] BUS[18] BUS[19] BUS[20] BUS[21] BUS[22] BUS[23] BUS[24] BUS[25] PIN[58] VDDd VSSd
+ enable Q_out[1369] Q_out[1370] Q_out[1371] Q_out[1372] Q_out[1373] Q_out[1374] Q_out[1375] Q_out[1376] Q_out[1377] Q_out[1378]
+ Q_out[1379] Q_out[1380] Q_out[1381] Q_out[1382] Q_out[1383] Q_out[1384] Q_out[1385] Q_out[1386] Q_out[1387] Q_out[1388] Q_out[1389]
+ Q_out[1390] Q_out[1391] Q_out[1392] swmatrix_row_25_w_clkbuf
xswmatrix_row[59] D_out_row[58] D_out_row[59] PHI_1 PHI_2 BUS[1] BUS[2] BUS[3] BUS[4] BUS[5] BUS[6] BUS[7] BUS[8] BUS[9] BUS[10]
+ BUS[11] BUS[12] BUS[13] BUS[14] BUS[15] BUS[16] BUS[17] BUS[18] BUS[19] BUS[20] BUS[21] BUS[22] BUS[23] BUS[24] BUS[25] PIN[59] VDDd VSSd
+ enable Q_out[1393] Q_out[1394] Q_out[1395] Q_out[1396] Q_out[1397] Q_out[1398] Q_out[1399] Q_out[1400] Q_out[1401] Q_out[1402]
+ Q_out[1403] Q_out[1404] Q_out[1405] Q_out[1406] Q_out[1407] Q_out[1408] Q_out[1409] Q_out[1410] Q_out[1411] Q_out[1412] Q_out[1413]
+ Q_out[1414] Q_out[1415] Q_out[1416] swmatrix_row_25_w_clkbuf
xswmatrix_row[60] D_out_row[59] D_out_row[60] PHI_1 PHI_2 BUS[1] BUS[2] BUS[3] BUS[4] BUS[5] BUS[6] BUS[7] BUS[8] BUS[9] BUS[10]
+ BUS[11] BUS[12] BUS[13] BUS[14] BUS[15] BUS[16] BUS[17] BUS[18] BUS[19] BUS[20] BUS[21] BUS[22] BUS[23] BUS[24] BUS[25] PIN[60] VDDd VSSd
+ enable Q_out[1417] Q_out[1418] Q_out[1419] Q_out[1420] Q_out[1421] Q_out[1422] Q_out[1423] Q_out[1424] Q_out[1425] Q_out[1426]
+ Q_out[1427] Q_out[1428] Q_out[1429] Q_out[1430] Q_out[1431] Q_out[1432] Q_out[1433] Q_out[1434] Q_out[1435] Q_out[1436] Q_out[1437]
+ Q_out[1438] Q_out[1439] Q_out[1440] swmatrix_row_25_w_clkbuf
xswmatrix_row[61] D_out_row[60] D_out_row[61] PHI_1 PHI_2 BUS[1] BUS[2] BUS[3] BUS[4] BUS[5] BUS[6] BUS[7] BUS[8] BUS[9] BUS[10]
+ BUS[11] BUS[12] BUS[13] BUS[14] BUS[15] BUS[16] BUS[17] BUS[18] BUS[19] BUS[20] BUS[21] BUS[22] BUS[23] BUS[24] BUS[25] PIN[61] VDDd VSSd
+ enable Q_out[1441] Q_out[1442] Q_out[1443] Q_out[1444] Q_out[1445] Q_out[1446] Q_out[1447] Q_out[1448] Q_out[1449] Q_out[1450]
+ Q_out[1451] Q_out[1452] Q_out[1453] Q_out[1454] Q_out[1455] Q_out[1456] Q_out[1457] Q_out[1458] Q_out[1459] Q_out[1460] Q_out[1461]
+ Q_out[1462] Q_out[1463] Q_out[1464] swmatrix_row_25_w_clkbuf
xswmatrix_row[62] D_out_row[61] D_out PHI_1 PHI_2 BUS[1] BUS[2] BUS[3] BUS[4] BUS[5] BUS[6] BUS[7] BUS[8] BUS[9] BUS[10] BUS[11]
+ BUS[12] BUS[13] BUS[14] BUS[15] BUS[16] BUS[17] BUS[18] BUS[19] BUS[20] BUS[21] BUS[22] BUS[23] BUS[24] BUS[25] PIN[62] VDDd VSSd enable
+ Q_out[1465] Q_out[1466] Q_out[1467] Q_out[1468] Q_out[1469] Q_out[1470] Q_out[1471] Q_out[1472] Q_out[1473] Q_out[1474] Q_out[1475]
+ Q_out[1476] Q_out[1477] Q_out[1478] Q_out[1479] Q_out[1480] Q_out[1481] Q_out[1482] Q_out[1483] Q_out[1484] Q_out[1485] Q_out[1486]
+ Q_out[1487] Q_out[1488] swmatrix_row_25_w_clkbuf
.ends

* expanding   symbol:  switch_matrix_gf180mcu_9t5v0/digital_interface_and_clock_gen/digital_interface_and_clock_gen.sym # of
*+ pins=9
** sym_path: /foss/designs/libs/switch_matrix_gf180mcu_9t5v0/digital_interface_and_clock_gen/digital_interface_and_clock_gen.sym
** sch_path: /foss/designs/libs/switch_matrix_gf180mcu_9t5v0/digital_interface_and_clock_gen/digital_interface_and_clock_gen.sch
.subckt digital_interface_and_clock_gen data data_out clock PHI_1 PHI_2 enable enable_out VDDd VSSd
*.PININFO data:I clock:I enable:I VSSd:B VDDd:B data_out:O PHI_1:O PHI_2:O enable_out:O
xNO_ClkGen PHI_2_gen clock_gated PHI_1_gen VDDd VSSd NO_ClkGen
x6 PHI_2_gen net1 VDDd VDDd VSSd VSSd gf180mcu_fd_sc_mcu9t5v0__inv_4
x7 net1 PHI_2 VDDd VDDd VSSd VSSd gf180mcu_fd_sc_mcu9t5v0__inv_8
x9 PHI_1_gen net2 VDDd VDDd VSSd VSSd gf180mcu_fd_sc_mcu9t5v0__inv_4
x10 net2 PHI_1 VDDd VDDd VSSd VSSd gf180mcu_fd_sc_mcu9t5v0__inv_8
x12 data_gated net3 VDDd VDDd VSSd VSSd gf180mcu_fd_sc_mcu9t5v0__inv_4
x13 net3 net8 VDDd VDDd VSSd VSSd gf180mcu_fd_sc_mcu9t5v0__inv_8
x2 net7 net4 VDDd VDDd VSSd VSSd gf180mcu_fd_sc_mcu9t5v0__inv_4
x8 net4 enable_out VDDd VDDd VSSd VSSd gf180mcu_fd_sc_mcu9t5v0__inv_8
x11 net5 net4 net10 VDDd VDDd VSSd VSSd gf180mcu_fd_sc_mcu9t5v0__nand2_4
x4 net6 net4 net11 VDDd VDDd VSSd VSSd gf180mcu_fd_sc_mcu9t5v0__nand2_4
x1 net11 clock_gated VDDd VDDd VSSd VSSd gf180mcu_fd_sc_mcu9t5v0__inv_4
x3 net10 data_gated VDDd VDDd VSSd VSSd gf180mcu_fd_sc_mcu9t5v0__inv_4
x5 VDDd clock net6 VSSd Schmitt
x14 VDDd data net5 VSSd Schmitt
x15 VDDd enable net7 VSSd Schmitt
XR1 VSSd enable VSSd ppolyf_u r_width=1e-6 r_length=20e-6 m=2
x16 net8 net9 VDDd VDDd VSSd VSSd gf180mcu_fd_sc_mcu9t5v0__inv_12
x17 net9 data_out VDDd VDDd VSSd VSSd gf180mcu_fd_sc_mcu9t5v0__inv_20
.ends

* expanding   symbol:  switch_matrix_gf180mcu_9t5v0/PHI_CLK_buf/PHI_CLK_buf.sym # of pins=4
** sym_path: /foss/designs/libs/switch_matrix_gf180mcu_9t5v0/PHI_CLK_buf/PHI_CLK_buf.sym
** sch_path: /foss/designs/libs/switch_matrix_gf180mcu_9t5v0/PHI_CLK_buf/PHI_CLK_buf.sch
.subckt PHI_CLK_buf CLK_buf CLK_in VDDd VSSd
*.PININFO CLK_in:I CLK_buf:O VDDd:B VSSd:B
x1 CLK_in net1 VDDd VDDd VSSd VSSd gf180mcu_fd_sc_mcu9t5v0__inv_8
x2 net1 net2 VDDd VDDd VSSd VSSd gf180mcu_fd_sc_mcu9t5v0__inv_12
x4 net3 CLK_buf VDDd VDDd VSSd VSSd gf180mcu_fd_sc_mcu9t5v0__inv_20
x3 net2 net3 VDDd VDDd VSSd VSSd gf180mcu_fd_sc_mcu9t5v0__inv_20
x5 net3 CLK_buf VDDd VDDd VSSd VSSd gf180mcu_fd_sc_mcu9t5v0__inv_20
* noconn VDDd
* noconn VSSd
.ends

* expanding   symbol:  switch_matrix_gf180mcu_9t5v0/swmatrix_68_by_25/swmatrix_68_by_25.sym # of pins=11
** sym_path: /foss/designs/libs/switch_matrix_gf180mcu_9t5v0/swmatrix_68_by_25/swmatrix_68_by_25.sym
** sch_path: /foss/designs/libs/switch_matrix_gf180mcu_9t5v0/swmatrix_68_by_25/swmatrix_68_by_25.sch
.subckt swmatrix_68_by_25 D_in D_out PHI_1 PHI_2 BUS[1] BUS[2] BUS[3] BUS[4] BUS[5] BUS[6] BUS[7] BUS[8] BUS[9] BUS[10] BUS[11]
+ BUS[12] BUS[13] BUS[14] BUS[15] BUS[16] BUS[17] BUS[18] BUS[19] BUS[20] BUS[21] BUS[22] BUS[23] BUS[24] BUS[25] PIN[1] PIN[2] PIN[3]
+ PIN[4] PIN[5] PIN[6] PIN[7] PIN[8] PIN[9] PIN[10] PIN[11] PIN[12] PIN[13] PIN[14] PIN[15] PIN[16] PIN[17] PIN[18] PIN[19] PIN[20]
+ PIN[21] PIN[22] PIN[23] PIN[24] PIN[25] PIN[26] PIN[27] PIN[28] PIN[29] PIN[30] PIN[31] PIN[32] PIN[33] PIN[34] PIN[35] PIN[36] PIN[37]
+ PIN[38] PIN[39] PIN[40] PIN[41] PIN[42] PIN[43] PIN[44] PIN[45] PIN[46] PIN[47] PIN[48] PIN[49] PIN[50] PIN[51] PIN[52] PIN[53] PIN[54]
+ PIN[55] PIN[56] PIN[57] PIN[58] PIN[59] PIN[60] PIN[61] PIN[62] PIN[63] PIN[64] PIN[65] PIN[66] PIN[67] PIN[68] VDDd VSSd enable Q_out[1]
+ Q_out[2] Q_out[3] Q_out[4] Q_out[5] Q_out[6] Q_out[7] Q_out[8] Q_out[9] Q_out[10] Q_out[11] Q_out[12] Q_out[13] Q_out[14] Q_out[15]
+ Q_out[16] Q_out[17] Q_out[18] Q_out[19] Q_out[20] Q_out[21] Q_out[22] Q_out[23] Q_out[24] Q_out[25] Q_out[26] Q_out[27] Q_out[28] Q_out[29]
+ Q_out[30] Q_out[31] Q_out[32] Q_out[33] Q_out[34] Q_out[35] Q_out[36] Q_out[37] Q_out[38] Q_out[39] Q_out[40] Q_out[41] Q_out[42] Q_out[43]
+ Q_out[44] Q_out[45] Q_out[46] Q_out[47] Q_out[48] Q_out[49] Q_out[50] Q_out[51] Q_out[52] Q_out[53] Q_out[54] Q_out[55] Q_out[56] Q_out[57]
+ Q_out[58] Q_out[59] Q_out[60] Q_out[61] Q_out[62] Q_out[63] Q_out[64] Q_out[65] Q_out[66] Q_out[67] Q_out[68] Q_out[69] Q_out[70] Q_out[71]
+ Q_out[72] Q_out[73] Q_out[74] Q_out[75] Q_out[76] Q_out[77] Q_out[78] Q_out[79] Q_out[80] Q_out[81] Q_out[82] Q_out[83] Q_out[84] Q_out[85]
+ Q_out[86] Q_out[87] Q_out[88] Q_out[89] Q_out[90] Q_out[91] Q_out[92] Q_out[93] Q_out[94] Q_out[95] Q_out[96] Q_out[97] Q_out[98] Q_out[99]
+ Q_out[100] Q_out[101] Q_out[102] Q_out[103] Q_out[104] Q_out[105] Q_out[106] Q_out[107] Q_out[108] Q_out[109] Q_out[110] Q_out[111]
+ Q_out[112] Q_out[113] Q_out[114] Q_out[115] Q_out[116] Q_out[117] Q_out[118] Q_out[119] Q_out[120] Q_out[121] Q_out[122] Q_out[123]
+ Q_out[124] Q_out[125] Q_out[126] Q_out[127] Q_out[128] Q_out[129] Q_out[130] Q_out[131] Q_out[132] Q_out[133] Q_out[134] Q_out[135]
+ Q_out[136] Q_out[137] Q_out[138] Q_out[139] Q_out[140] Q_out[141] Q_out[142] Q_out[143] Q_out[144] Q_out[145] Q_out[146] Q_out[147]
+ Q_out[148] Q_out[149] Q_out[150] Q_out[151] Q_out[152] Q_out[153] Q_out[154] Q_out[155] Q_out[156] Q_out[157] Q_out[158] Q_out[159]
+ Q_out[160] Q_out[161] Q_out[162] Q_out[163] Q_out[164] Q_out[165] Q_out[166] Q_out[167] Q_out[168] Q_out[169] Q_out[170] Q_out[171]
+ Q_out[172] Q_out[173] Q_out[174] Q_out[175] Q_out[176] Q_out[177] Q_out[178] Q_out[179] Q_out[180] Q_out[181] Q_out[182] Q_out[183]
+ Q_out[184] Q_out[185] Q_out[186] Q_out[187] Q_out[188] Q_out[189] Q_out[190] Q_out[191] Q_out[192] Q_out[193] Q_out[194] Q_out[195]
+ Q_out[196] Q_out[197] Q_out[198] Q_out[199] Q_out[200] Q_out[201] Q_out[202] Q_out[203] Q_out[204] Q_out[205] Q_out[206] Q_out[207]
+ Q_out[208] Q_out[209] Q_out[210] Q_out[211] Q_out[212] Q_out[213] Q_out[214] Q_out[215] Q_out[216] Q_out[217] Q_out[218] Q_out[219]
+ Q_out[220] Q_out[221] Q_out[222] Q_out[223] Q_out[224] Q_out[225] Q_out[226] Q_out[227] Q_out[228] Q_out[229] Q_out[230] Q_out[231]
+ Q_out[232] Q_out[233] Q_out[234] Q_out[235] Q_out[236] Q_out[237] Q_out[238] Q_out[239] Q_out[240] Q_out[241] Q_out[242] Q_out[243]
+ Q_out[244] Q_out[245] Q_out[246] Q_out[247] Q_out[248] Q_out[249] Q_out[250] Q_out[251] Q_out[252] Q_out[253] Q_out[254] Q_out[255]
+ Q_out[256] Q_out[257] Q_out[258] Q_out[259] Q_out[260] Q_out[261] Q_out[262] Q_out[263] Q_out[264] Q_out[265] Q_out[266] Q_out[267]
+ Q_out[268] Q_out[269] Q_out[270] Q_out[271] Q_out[272] Q_out[273] Q_out[274] Q_out[275] Q_out[276] Q_out[277] Q_out[278] Q_out[279]
+ Q_out[280] Q_out[281] Q_out[282] Q_out[283] Q_out[284] Q_out[285] Q_out[286] Q_out[287] Q_out[288] Q_out[289] Q_out[290] Q_out[291]
+ Q_out[292] Q_out[293] Q_out[294] Q_out[295] Q_out[296] Q_out[297] Q_out[298] Q_out[299] Q_out[300] Q_out[301] Q_out[302] Q_out[303]
+ Q_out[304] Q_out[305] Q_out[306] Q_out[307] Q_out[308] Q_out[309] Q_out[310] Q_out[311] Q_out[312] Q_out[313] Q_out[314] Q_out[315]
+ Q_out[316] Q_out[317] Q_out[318] Q_out[319] Q_out[320] Q_out[321] Q_out[322] Q_out[323] Q_out[324] Q_out[325] Q_out[326] Q_out[327]
+ Q_out[328] Q_out[329] Q_out[330] Q_out[331] Q_out[332] Q_out[333] Q_out[334] Q_out[335] Q_out[336] Q_out[337] Q_out[338] Q_out[339]
+ Q_out[340] Q_out[341] Q_out[342] Q_out[343] Q_out[344] Q_out[345] Q_out[346] Q_out[347] Q_out[348] Q_out[349] Q_out[350] Q_out[351]
+ Q_out[352] Q_out[353] Q_out[354] Q_out[355] Q_out[356] Q_out[357] Q_out[358] Q_out[359] Q_out[360] Q_out[361] Q_out[362] Q_out[363]
+ Q_out[364] Q_out[365] Q_out[366] Q_out[367] Q_out[368] Q_out[369] Q_out[370] Q_out[371] Q_out[372] Q_out[373] Q_out[374] Q_out[375]
+ Q_out[376] Q_out[377] Q_out[378] Q_out[379] Q_out[380] Q_out[381] Q_out[382] Q_out[383] Q_out[384] Q_out[385] Q_out[386] Q_out[387]
+ Q_out[388] Q_out[389] Q_out[390] Q_out[391] Q_out[392] Q_out[393] Q_out[394] Q_out[395] Q_out[396] Q_out[397] Q_out[398] Q_out[399]
+ Q_out[400] Q_out[401] Q_out[402] Q_out[403] Q_out[404] Q_out[405] Q_out[406] Q_out[407] Q_out[408] Q_out[409] Q_out[410] Q_out[411]
+ Q_out[412] Q_out[413] Q_out[414] Q_out[415] Q_out[416] Q_out[417] Q_out[418] Q_out[419] Q_out[420] Q_out[421] Q_out[422] Q_out[423]
+ Q_out[424] Q_out[425] Q_out[426] Q_out[427] Q_out[428] Q_out[429] Q_out[430] Q_out[431] Q_out[432] Q_out[433] Q_out[434] Q_out[435]
+ Q_out[436] Q_out[437] Q_out[438] Q_out[439] Q_out[440] Q_out[441] Q_out[442] Q_out[443] Q_out[444] Q_out[445] Q_out[446] Q_out[447]
+ Q_out[448] Q_out[449] Q_out[450] Q_out[451] Q_out[452] Q_out[453] Q_out[454] Q_out[455] Q_out[456] Q_out[457] Q_out[458] Q_out[459]
+ Q_out[460] Q_out[461] Q_out[462] Q_out[463] Q_out[464] Q_out[465] Q_out[466] Q_out[467] Q_out[468] Q_out[469] Q_out[470] Q_out[471]
+ Q_out[472] Q_out[473] Q_out[474] Q_out[475] Q_out[476] Q_out[477] Q_out[478] Q_out[479] Q_out[480] Q_out[481] Q_out[482] Q_out[483]
+ Q_out[484] Q_out[485] Q_out[486] Q_out[487] Q_out[488] Q_out[489] Q_out[490] Q_out[491] Q_out[492] Q_out[493] Q_out[494] Q_out[495]
+ Q_out[496] Q_out[497] Q_out[498] Q_out[499] Q_out[500] Q_out[501] Q_out[502] Q_out[503] Q_out[504] Q_out[505] Q_out[506] Q_out[507]
+ Q_out[508] Q_out[509] Q_out[510] Q_out[511] Q_out[512] Q_out[513] Q_out[514] Q_out[515] Q_out[516] Q_out[517] Q_out[518] Q_out[519]
+ Q_out[520] Q_out[521] Q_out[522] Q_out[523] Q_out[524] Q_out[525] Q_out[526] Q_out[527] Q_out[528] Q_out[529] Q_out[530] Q_out[531]
+ Q_out[532] Q_out[533] Q_out[534] Q_out[535] Q_out[536] Q_out[537] Q_out[538] Q_out[539] Q_out[540] Q_out[541] Q_out[542] Q_out[543]
+ Q_out[544] Q_out[545] Q_out[546] Q_out[547] Q_out[548] Q_out[549] Q_out[550] Q_out[551] Q_out[552] Q_out[553] Q_out[554] Q_out[555]
+ Q_out[556] Q_out[557] Q_out[558] Q_out[559] Q_out[560] Q_out[561] Q_out[562] Q_out[563] Q_out[564] Q_out[565] Q_out[566] Q_out[567]
+ Q_out[568] Q_out[569] Q_out[570] Q_out[571] Q_out[572] Q_out[573] Q_out[574] Q_out[575] Q_out[576] Q_out[577] Q_out[578] Q_out[579]
+ Q_out[580] Q_out[581] Q_out[582] Q_out[583] Q_out[584] Q_out[585] Q_out[586] Q_out[587] Q_out[588] Q_out[589] Q_out[590] Q_out[591]
+ Q_out[592] Q_out[593] Q_out[594] Q_out[595] Q_out[596] Q_out[597] Q_out[598] Q_out[599] Q_out[600] Q_out[601] Q_out[602] Q_out[603]
+ Q_out[604] Q_out[605] Q_out[606] Q_out[607] Q_out[608] Q_out[609] Q_out[610] Q_out[611] Q_out[612] Q_out[613] Q_out[614] Q_out[615]
+ Q_out[616] Q_out[617] Q_out[618] Q_out[619] Q_out[620] Q_out[621] Q_out[622] Q_out[623] Q_out[624] Q_out[625] Q_out[626] Q_out[627]
+ Q_out[628] Q_out[629] Q_out[630] Q_out[631] Q_out[632] Q_out[633] Q_out[634] Q_out[635] Q_out[636] Q_out[637] Q_out[638] Q_out[639]
+ Q_out[640] Q_out[641] Q_out[642] Q_out[643] Q_out[644] Q_out[645] Q_out[646] Q_out[647] Q_out[648] Q_out[649] Q_out[650] Q_out[651]
+ Q_out[652] Q_out[653] Q_out[654] Q_out[655] Q_out[656] Q_out[657] Q_out[658] Q_out[659] Q_out[660] Q_out[661] Q_out[662] Q_out[663]
+ Q_out[664] Q_out[665] Q_out[666] Q_out[667] Q_out[668] Q_out[669] Q_out[670] Q_out[671] Q_out[672] Q_out[673] Q_out[674] Q_out[675]
+ Q_out[676] Q_out[677] Q_out[678] Q_out[679] Q_out[680] Q_out[681] Q_out[682] Q_out[683] Q_out[684] Q_out[685] Q_out[686] Q_out[687]
+ Q_out[688] Q_out[689] Q_out[690] Q_out[691] Q_out[692] Q_out[693] Q_out[694] Q_out[695] Q_out[696] Q_out[697] Q_out[698] Q_out[699]
+ Q_out[700] Q_out[701] Q_out[702] Q_out[703] Q_out[704] Q_out[705] Q_out[706] Q_out[707] Q_out[708] Q_out[709] Q_out[710] Q_out[711]
+ Q_out[712] Q_out[713] Q_out[714] Q_out[715] Q_out[716] Q_out[717] Q_out[718] Q_out[719] Q_out[720] Q_out[721] Q_out[722] Q_out[723]
+ Q_out[724] Q_out[725] Q_out[726] Q_out[727] Q_out[728] Q_out[729] Q_out[730] Q_out[731] Q_out[732] Q_out[733] Q_out[734] Q_out[735]
+ Q_out[736] Q_out[737] Q_out[738] Q_out[739] Q_out[740] Q_out[741] Q_out[742] Q_out[743] Q_out[744] Q_out[745] Q_out[746] Q_out[747]
+ Q_out[748] Q_out[749] Q_out[750] Q_out[751] Q_out[752] Q_out[753] Q_out[754] Q_out[755] Q_out[756] Q_out[757] Q_out[758] Q_out[759]
+ Q_out[760] Q_out[761] Q_out[762] Q_out[763] Q_out[764] Q_out[765] Q_out[766] Q_out[767] Q_out[768] Q_out[769] Q_out[770] Q_out[771]
+ Q_out[772] Q_out[773] Q_out[774] Q_out[775] Q_out[776] Q_out[777] Q_out[778] Q_out[779] Q_out[780] Q_out[781] Q_out[782] Q_out[783]
+ Q_out[784] Q_out[785] Q_out[786] Q_out[787] Q_out[788] Q_out[789] Q_out[790] Q_out[791] Q_out[792] Q_out[793] Q_out[794] Q_out[795]
+ Q_out[796] Q_out[797] Q_out[798] Q_out[799] Q_out[800] Q_out[801] Q_out[802] Q_out[803] Q_out[804] Q_out[805] Q_out[806] Q_out[807]
+ Q_out[808] Q_out[809] Q_out[810] Q_out[811] Q_out[812] Q_out[813] Q_out[814] Q_out[815] Q_out[816] Q_out[817] Q_out[818] Q_out[819]
+ Q_out[820] Q_out[821] Q_out[822] Q_out[823] Q_out[824] Q_out[825] Q_out[826] Q_out[827] Q_out[828] Q_out[829] Q_out[830] Q_out[831]
+ Q_out[832] Q_out[833] Q_out[834] Q_out[835] Q_out[836] Q_out[837] Q_out[838] Q_out[839] Q_out[840] Q_out[841] Q_out[842] Q_out[843]
+ Q_out[844] Q_out[845] Q_out[846] Q_out[847] Q_out[848] Q_out[849] Q_out[850] Q_out[851] Q_out[852] Q_out[853] Q_out[854] Q_out[855]
+ Q_out[856] Q_out[857] Q_out[858] Q_out[859] Q_out[860] Q_out[861] Q_out[862] Q_out[863] Q_out[864] Q_out[865] Q_out[866] Q_out[867]
+ Q_out[868] Q_out[869] Q_out[870] Q_out[871] Q_out[872] Q_out[873] Q_out[874] Q_out[875] Q_out[876] Q_out[877] Q_out[878] Q_out[879]
+ Q_out[880] Q_out[881] Q_out[882] Q_out[883] Q_out[884] Q_out[885] Q_out[886] Q_out[887] Q_out[888] Q_out[889] Q_out[890] Q_out[891]
+ Q_out[892] Q_out[893] Q_out[894] Q_out[895] Q_out[896] Q_out[897] Q_out[898] Q_out[899] Q_out[900] Q_out[901] Q_out[902] Q_out[903]
+ Q_out[904] Q_out[905] Q_out[906] Q_out[907] Q_out[908] Q_out[909] Q_out[910] Q_out[911] Q_out[912] Q_out[913] Q_out[914] Q_out[915]
+ Q_out[916] Q_out[917] Q_out[918] Q_out[919] Q_out[920] Q_out[921] Q_out[922] Q_out[923] Q_out[924] Q_out[925] Q_out[926] Q_out[927]
+ Q_out[928] Q_out[929] Q_out[930] Q_out[931] Q_out[932] Q_out[933] Q_out[934] Q_out[935] Q_out[936] Q_out[937] Q_out[938] Q_out[939]
+ Q_out[940] Q_out[941] Q_out[942] Q_out[943] Q_out[944] Q_out[945] Q_out[946] Q_out[947] Q_out[948] Q_out[949] Q_out[950] Q_out[951]
+ Q_out[952] Q_out[953] Q_out[954] Q_out[955] Q_out[956] Q_out[957] Q_out[958] Q_out[959] Q_out[960] Q_out[961] Q_out[962] Q_out[963]
+ Q_out[964] Q_out[965] Q_out[966] Q_out[967] Q_out[968] Q_out[969] Q_out[970] Q_out[971] Q_out[972] Q_out[973] Q_out[974] Q_out[975]
+ Q_out[976] Q_out[977] Q_out[978] Q_out[979] Q_out[980] Q_out[981] Q_out[982] Q_out[983] Q_out[984] Q_out[985] Q_out[986] Q_out[987]
+ Q_out[988] Q_out[989] Q_out[990] Q_out[991] Q_out[992] Q_out[993] Q_out[994] Q_out[995] Q_out[996] Q_out[997] Q_out[998] Q_out[999]
+ Q_out[1000] Q_out[1001] Q_out[1002] Q_out[1003] Q_out[1004] Q_out[1005] Q_out[1006] Q_out[1007] Q_out[1008] Q_out[1009] Q_out[1010]
+ Q_out[1011] Q_out[1012] Q_out[1013] Q_out[1014] Q_out[1015] Q_out[1016] Q_out[1017] Q_out[1018] Q_out[1019] Q_out[1020] Q_out[1021]
+ Q_out[1022] Q_out[1023] Q_out[1024] Q_out[1025] Q_out[1026] Q_out[1027] Q_out[1028] Q_out[1029] Q_out[1030] Q_out[1031] Q_out[1032]
+ Q_out[1033] Q_out[1034] Q_out[1035] Q_out[1036] Q_out[1037] Q_out[1038] Q_out[1039] Q_out[1040] Q_out[1041] Q_out[1042] Q_out[1043]
+ Q_out[1044] Q_out[1045] Q_out[1046] Q_out[1047] Q_out[1048] Q_out[1049] Q_out[1050] Q_out[1051] Q_out[1052] Q_out[1053] Q_out[1054]
+ Q_out[1055] Q_out[1056] Q_out[1057] Q_out[1058] Q_out[1059] Q_out[1060] Q_out[1061] Q_out[1062] Q_out[1063] Q_out[1064] Q_out[1065]
+ Q_out[1066] Q_out[1067] Q_out[1068] Q_out[1069] Q_out[1070] Q_out[1071] Q_out[1072] Q_out[1073] Q_out[1074] Q_out[1075] Q_out[1076]
+ Q_out[1077] Q_out[1078] Q_out[1079] Q_out[1080] Q_out[1081] Q_out[1082] Q_out[1083] Q_out[1084] Q_out[1085] Q_out[1086] Q_out[1087]
+ Q_out[1088] Q_out[1089] Q_out[1090] Q_out[1091] Q_out[1092] Q_out[1093] Q_out[1094] Q_out[1095] Q_out[1096] Q_out[1097] Q_out[1098]
+ Q_out[1099] Q_out[1100] Q_out[1101] Q_out[1102] Q_out[1103] Q_out[1104] Q_out[1105] Q_out[1106] Q_out[1107] Q_out[1108] Q_out[1109]
+ Q_out[1110] Q_out[1111] Q_out[1112] Q_out[1113] Q_out[1114] Q_out[1115] Q_out[1116] Q_out[1117] Q_out[1118] Q_out[1119] Q_out[1120]
+ Q_out[1121] Q_out[1122] Q_out[1123] Q_out[1124] Q_out[1125] Q_out[1126] Q_out[1127] Q_out[1128] Q_out[1129] Q_out[1130] Q_out[1131]
+ Q_out[1132] Q_out[1133] Q_out[1134] Q_out[1135] Q_out[1136] Q_out[1137] Q_out[1138] Q_out[1139] Q_out[1140] Q_out[1141] Q_out[1142]
+ Q_out[1143] Q_out[1144] Q_out[1145] Q_out[1146] Q_out[1147] Q_out[1148] Q_out[1149] Q_out[1150] Q_out[1151] Q_out[1152] Q_out[1153]
+ Q_out[1154] Q_out[1155] Q_out[1156] Q_out[1157] Q_out[1158] Q_out[1159] Q_out[1160] Q_out[1161] Q_out[1162] Q_out[1163] Q_out[1164]
+ Q_out[1165] Q_out[1166] Q_out[1167] Q_out[1168] Q_out[1169] Q_out[1170] Q_out[1171] Q_out[1172] Q_out[1173] Q_out[1174] Q_out[1175]
+ Q_out[1176] Q_out[1177] Q_out[1178] Q_out[1179] Q_out[1180] Q_out[1181] Q_out[1182] Q_out[1183] Q_out[1184] Q_out[1185] Q_out[1186]
+ Q_out[1187] Q_out[1188] Q_out[1189] Q_out[1190] Q_out[1191] Q_out[1192] Q_out[1193] Q_out[1194] Q_out[1195] Q_out[1196] Q_out[1197]
+ Q_out[1198] Q_out[1199] Q_out[1200] Q_out[1201] Q_out[1202] Q_out[1203] Q_out[1204] Q_out[1205] Q_out[1206] Q_out[1207] Q_out[1208]
+ Q_out[1209] Q_out[1210] Q_out[1211] Q_out[1212] Q_out[1213] Q_out[1214] Q_out[1215] Q_out[1216] Q_out[1217] Q_out[1218] Q_out[1219]
+ Q_out[1220] Q_out[1221] Q_out[1222] Q_out[1223] Q_out[1224] Q_out[1225] Q_out[1226] Q_out[1227] Q_out[1228] Q_out[1229] Q_out[1230]
+ Q_out[1231] Q_out[1232] Q_out[1233] Q_out[1234] Q_out[1235] Q_out[1236] Q_out[1237] Q_out[1238] Q_out[1239] Q_out[1240] Q_out[1241]
+ Q_out[1242] Q_out[1243] Q_out[1244] Q_out[1245] Q_out[1246] Q_out[1247] Q_out[1248] Q_out[1249] Q_out[1250] Q_out[1251] Q_out[1252]
+ Q_out[1253] Q_out[1254] Q_out[1255] Q_out[1256] Q_out[1257] Q_out[1258] Q_out[1259] Q_out[1260] Q_out[1261] Q_out[1262] Q_out[1263]
+ Q_out[1264] Q_out[1265] Q_out[1266] Q_out[1267] Q_out[1268] Q_out[1269] Q_out[1270] Q_out[1271] Q_out[1272] Q_out[1273] Q_out[1274]
+ Q_out[1275] Q_out[1276] Q_out[1277] Q_out[1278] Q_out[1279] Q_out[1280] Q_out[1281] Q_out[1282] Q_out[1283] Q_out[1284] Q_out[1285]
+ Q_out[1286] Q_out[1287] Q_out[1288] Q_out[1289] Q_out[1290] Q_out[1291] Q_out[1292] Q_out[1293] Q_out[1294] Q_out[1295] Q_out[1296]
+ Q_out[1297] Q_out[1298] Q_out[1299] Q_out[1300] Q_out[1301] Q_out[1302] Q_out[1303] Q_out[1304] Q_out[1305] Q_out[1306] Q_out[1307]
+ Q_out[1308] Q_out[1309] Q_out[1310] Q_out[1311] Q_out[1312] Q_out[1313] Q_out[1314] Q_out[1315] Q_out[1316] Q_out[1317] Q_out[1318]
+ Q_out[1319] Q_out[1320] Q_out[1321] Q_out[1322] Q_out[1323] Q_out[1324] Q_out[1325] Q_out[1326] Q_out[1327] Q_out[1328] Q_out[1329]
+ Q_out[1330] Q_out[1331] Q_out[1332] Q_out[1333] Q_out[1334] Q_out[1335] Q_out[1336] Q_out[1337] Q_out[1338] Q_out[1339] Q_out[1340]
+ Q_out[1341] Q_out[1342] Q_out[1343] Q_out[1344] Q_out[1345] Q_out[1346] Q_out[1347] Q_out[1348] Q_out[1349] Q_out[1350] Q_out[1351]
+ Q_out[1352] Q_out[1353] Q_out[1354] Q_out[1355] Q_out[1356] Q_out[1357] Q_out[1358] Q_out[1359] Q_out[1360] Q_out[1361] Q_out[1362]
+ Q_out[1363] Q_out[1364] Q_out[1365] Q_out[1366] Q_out[1367] Q_out[1368] Q_out[1369] Q_out[1370] Q_out[1371] Q_out[1372] Q_out[1373]
+ Q_out[1374] Q_out[1375] Q_out[1376] Q_out[1377] Q_out[1378] Q_out[1379] Q_out[1380] Q_out[1381] Q_out[1382] Q_out[1383] Q_out[1384]
+ Q_out[1385] Q_out[1386] Q_out[1387] Q_out[1388] Q_out[1389] Q_out[1390] Q_out[1391] Q_out[1392] Q_out[1393] Q_out[1394] Q_out[1395]
+ Q_out[1396] Q_out[1397] Q_out[1398] Q_out[1399] Q_out[1400] Q_out[1401] Q_out[1402] Q_out[1403] Q_out[1404] Q_out[1405] Q_out[1406]
+ Q_out[1407] Q_out[1408] Q_out[1409] Q_out[1410] Q_out[1411] Q_out[1412] Q_out[1413] Q_out[1414] Q_out[1415] Q_out[1416] Q_out[1417]
+ Q_out[1418] Q_out[1419] Q_out[1420] Q_out[1421] Q_out[1422] Q_out[1423] Q_out[1424] Q_out[1425] Q_out[1426] Q_out[1427] Q_out[1428]
+ Q_out[1429] Q_out[1430] Q_out[1431] Q_out[1432] Q_out[1433] Q_out[1434] Q_out[1435] Q_out[1436] Q_out[1437] Q_out[1438] Q_out[1439]
+ Q_out[1440] Q_out[1441] Q_out[1442] Q_out[1443] Q_out[1444] Q_out[1445] Q_out[1446] Q_out[1447] Q_out[1448] Q_out[1449] Q_out[1450]
+ Q_out[1451] Q_out[1452] Q_out[1453] Q_out[1454] Q_out[1455] Q_out[1456] Q_out[1457] Q_out[1458] Q_out[1459] Q_out[1460] Q_out[1461]
+ Q_out[1462] Q_out[1463] Q_out[1464] Q_out[1465] Q_out[1466] Q_out[1467] Q_out[1468] Q_out[1469] Q_out[1470] Q_out[1471] Q_out[1472]
+ Q_out[1473] Q_out[1474] Q_out[1475] Q_out[1476] Q_out[1477] Q_out[1478] Q_out[1479] Q_out[1480] Q_out[1481] Q_out[1482] Q_out[1483]
+ Q_out[1484] Q_out[1485] Q_out[1486] Q_out[1487] Q_out[1488] Q_out[1489] Q_out[1490] Q_out[1491] Q_out[1492] Q_out[1493] Q_out[1494]
+ Q_out[1495] Q_out[1496] Q_out[1497] Q_out[1498] Q_out[1499] Q_out[1500] Q_out[1501] Q_out[1502] Q_out[1503] Q_out[1504] Q_out[1505]
+ Q_out[1506] Q_out[1507] Q_out[1508] Q_out[1509] Q_out[1510] Q_out[1511] Q_out[1512] Q_out[1513] Q_out[1514] Q_out[1515] Q_out[1516]
+ Q_out[1517] Q_out[1518] Q_out[1519] Q_out[1520] Q_out[1521] Q_out[1522] Q_out[1523] Q_out[1524] Q_out[1525] Q_out[1526] Q_out[1527]
+ Q_out[1528] Q_out[1529] Q_out[1530] Q_out[1531] Q_out[1532] Q_out[1533] Q_out[1534] Q_out[1535] Q_out[1536] Q_out[1537] Q_out[1538]
+ Q_out[1539] Q_out[1540] Q_out[1541] Q_out[1542] Q_out[1543] Q_out[1544] Q_out[1545] Q_out[1546] Q_out[1547] Q_out[1548] Q_out[1549]
+ Q_out[1550] Q_out[1551] Q_out[1552] Q_out[1553] Q_out[1554] Q_out[1555] Q_out[1556] Q_out[1557] Q_out[1558] Q_out[1559] Q_out[1560]
+ Q_out[1561] Q_out[1562] Q_out[1563] Q_out[1564] Q_out[1565] Q_out[1566] Q_out[1567] Q_out[1568] Q_out[1569] Q_out[1570] Q_out[1571]
+ Q_out[1572] Q_out[1573] Q_out[1574] Q_out[1575] Q_out[1576] Q_out[1577] Q_out[1578] Q_out[1579] Q_out[1580] Q_out[1581] Q_out[1582]
+ Q_out[1583] Q_out[1584] Q_out[1585] Q_out[1586] Q_out[1587] Q_out[1588] Q_out[1589] Q_out[1590] Q_out[1591] Q_out[1592] Q_out[1593]
+ Q_out[1594] Q_out[1595] Q_out[1596] Q_out[1597] Q_out[1598] Q_out[1599] Q_out[1600] Q_out[1601] Q_out[1602] Q_out[1603] Q_out[1604]
+ Q_out[1605] Q_out[1606] Q_out[1607] Q_out[1608] Q_out[1609] Q_out[1610] Q_out[1611] Q_out[1612] Q_out[1613] Q_out[1614] Q_out[1615]
+ Q_out[1616] Q_out[1617] Q_out[1618] Q_out[1619] Q_out[1620] Q_out[1621] Q_out[1622] Q_out[1623] Q_out[1624] Q_out[1625] Q_out[1626]
+ Q_out[1627] Q_out[1628] Q_out[1629] Q_out[1630] Q_out[1631] Q_out[1632] D_out_row[1] D_out_row[2] D_out_row[3] D_out_row[4] D_out_row[5]
+ D_out_row[6] D_out_row[7] D_out_row[8] D_out_row[9] D_out_row[10] D_out_row[11] D_out_row[12] D_out_row[13] D_out_row[14] D_out_row[15]
+ D_out_row[16] D_out_row[17] D_out_row[18] D_out_row[19] D_out_row[20] D_out_row[21] D_out_row[22] D_out_row[23] D_out_row[24] D_out_row[25]
+ D_out_row[26] D_out_row[27] D_out_row[28] D_out_row[29] D_out_row[30] D_out_row[31] D_out_row[32] D_out_row[33] D_out_row[34] D_out_row[35]
+ D_out_row[36] D_out_row[37] D_out_row[38] D_out_row[39] D_out_row[40] D_out_row[41] D_out_row[42] D_out_row[43] D_out_row[44] D_out_row[45]
+ D_out_row[46] D_out_row[47] D_out_row[48] D_out_row[49] D_out_row[50] D_out_row[51] D_out_row[52] D_out_row[53] D_out_row[54] D_out_row[55]
+ D_out_row[56] D_out_row[57] D_out_row[58] D_out_row[59] D_out_row[60] D_out_row[61] D_out_row[62] D_out_row[63] D_out_row[64] D_out_row[65]
+ D_out_row[66] D_out_row[67]
*.PININFO PIN[1:68]:B BUS[1:25]:B PHI_1:I PHI_2:I D_in:I Q_out[1:1632]:B VDDd:B VSSd:B enable:I D_out:B D_out_row[1:67]:B
xswmatrix_row[1] D_in D_out_row[1] PHI_1 PHI_2 BUS[1] BUS[2] BUS[3] BUS[4] BUS[5] BUS[6] BUS[7] BUS[8] BUS[9] BUS[10] BUS[11]
+ BUS[12] BUS[13] BUS[14] BUS[15] BUS[16] BUS[17] BUS[18] BUS[19] BUS[20] BUS[21] BUS[22] BUS[23] BUS[24] BUS[25] PIN[1] VDDd VSSd enable
+ Q_out[1] Q_out[2] Q_out[3] Q_out[4] Q_out[5] Q_out[6] Q_out[7] Q_out[8] Q_out[9] Q_out[10] Q_out[11] Q_out[12] Q_out[13] Q_out[14]
+ Q_out[15] Q_out[16] Q_out[17] Q_out[18] Q_out[19] Q_out[20] Q_out[21] Q_out[22] Q_out[23] Q_out[24] swmatrix_row_25_w_clkbuf
xswmatrix_row[2] D_out_row[1] D_out_row[2] PHI_1 PHI_2 BUS[1] BUS[2] BUS[3] BUS[4] BUS[5] BUS[6] BUS[7] BUS[8] BUS[9] BUS[10]
+ BUS[11] BUS[12] BUS[13] BUS[14] BUS[15] BUS[16] BUS[17] BUS[18] BUS[19] BUS[20] BUS[21] BUS[22] BUS[23] BUS[24] BUS[25] PIN[2] VDDd VSSd
+ enable Q_out[25] Q_out[26] Q_out[27] Q_out[28] Q_out[29] Q_out[30] Q_out[31] Q_out[32] Q_out[33] Q_out[34] Q_out[35] Q_out[36] Q_out[37]
+ Q_out[38] Q_out[39] Q_out[40] Q_out[41] Q_out[42] Q_out[43] Q_out[44] Q_out[45] Q_out[46] Q_out[47] Q_out[48] swmatrix_row_25_w_clkbuf
xswmatrix_row[3] D_out_row[2] D_out_row[3] PHI_1 PHI_2 BUS[1] BUS[2] BUS[3] BUS[4] BUS[5] BUS[6] BUS[7] BUS[8] BUS[9] BUS[10]
+ BUS[11] BUS[12] BUS[13] BUS[14] BUS[15] BUS[16] BUS[17] BUS[18] BUS[19] BUS[20] BUS[21] BUS[22] BUS[23] BUS[24] BUS[25] PIN[3] VDDd VSSd
+ enable Q_out[49] Q_out[50] Q_out[51] Q_out[52] Q_out[53] Q_out[54] Q_out[55] Q_out[56] Q_out[57] Q_out[58] Q_out[59] Q_out[60] Q_out[61]
+ Q_out[62] Q_out[63] Q_out[64] Q_out[65] Q_out[66] Q_out[67] Q_out[68] Q_out[69] Q_out[70] Q_out[71] Q_out[72] swmatrix_row_25_w_clkbuf
xswmatrix_row[4] D_out_row[3] D_out_row[4] PHI_1 PHI_2 BUS[1] BUS[2] BUS[3] BUS[4] BUS[5] BUS[6] BUS[7] BUS[8] BUS[9] BUS[10]
+ BUS[11] BUS[12] BUS[13] BUS[14] BUS[15] BUS[16] BUS[17] BUS[18] BUS[19] BUS[20] BUS[21] BUS[22] BUS[23] BUS[24] BUS[25] PIN[4] VDDd VSSd
+ enable Q_out[73] Q_out[74] Q_out[75] Q_out[76] Q_out[77] Q_out[78] Q_out[79] Q_out[80] Q_out[81] Q_out[82] Q_out[83] Q_out[84] Q_out[85]
+ Q_out[86] Q_out[87] Q_out[88] Q_out[89] Q_out[90] Q_out[91] Q_out[92] Q_out[93] Q_out[94] Q_out[95] Q_out[96] swmatrix_row_25_w_clkbuf
xswmatrix_row[5] D_out_row[4] D_out_row[5] PHI_1 PHI_2 BUS[1] BUS[2] BUS[3] BUS[4] BUS[5] BUS[6] BUS[7] BUS[8] BUS[9] BUS[10]
+ BUS[11] BUS[12] BUS[13] BUS[14] BUS[15] BUS[16] BUS[17] BUS[18] BUS[19] BUS[20] BUS[21] BUS[22] BUS[23] BUS[24] BUS[25] PIN[5] VDDd VSSd
+ enable Q_out[97] Q_out[98] Q_out[99] Q_out[100] Q_out[101] Q_out[102] Q_out[103] Q_out[104] Q_out[105] Q_out[106] Q_out[107] Q_out[108]
+ Q_out[109] Q_out[110] Q_out[111] Q_out[112] Q_out[113] Q_out[114] Q_out[115] Q_out[116] Q_out[117] Q_out[118] Q_out[119] Q_out[120]
+ swmatrix_row_25_w_clkbuf
xswmatrix_row[6] D_out_row[5] D_out_row[6] PHI_1 PHI_2 BUS[1] BUS[2] BUS[3] BUS[4] BUS[5] BUS[6] BUS[7] BUS[8] BUS[9] BUS[10]
+ BUS[11] BUS[12] BUS[13] BUS[14] BUS[15] BUS[16] BUS[17] BUS[18] BUS[19] BUS[20] BUS[21] BUS[22] BUS[23] BUS[24] BUS[25] PIN[6] VDDd VSSd
+ enable Q_out[121] Q_out[122] Q_out[123] Q_out[124] Q_out[125] Q_out[126] Q_out[127] Q_out[128] Q_out[129] Q_out[130] Q_out[131]
+ Q_out[132] Q_out[133] Q_out[134] Q_out[135] Q_out[136] Q_out[137] Q_out[138] Q_out[139] Q_out[140] Q_out[141] Q_out[142] Q_out[143]
+ Q_out[144] swmatrix_row_25_w_clkbuf
xswmatrix_row[7] D_out_row[6] D_out_row[7] PHI_1 PHI_2 BUS[1] BUS[2] BUS[3] BUS[4] BUS[5] BUS[6] BUS[7] BUS[8] BUS[9] BUS[10]
+ BUS[11] BUS[12] BUS[13] BUS[14] BUS[15] BUS[16] BUS[17] BUS[18] BUS[19] BUS[20] BUS[21] BUS[22] BUS[23] BUS[24] BUS[25] PIN[7] VDDd VSSd
+ enable Q_out[145] Q_out[146] Q_out[147] Q_out[148] Q_out[149] Q_out[150] Q_out[151] Q_out[152] Q_out[153] Q_out[154] Q_out[155]
+ Q_out[156] Q_out[157] Q_out[158] Q_out[159] Q_out[160] Q_out[161] Q_out[162] Q_out[163] Q_out[164] Q_out[165] Q_out[166] Q_out[167]
+ Q_out[168] swmatrix_row_25_w_clkbuf
xswmatrix_row[8] D_out_row[7] D_out_row[8] PHI_1 PHI_2 BUS[1] BUS[2] BUS[3] BUS[4] BUS[5] BUS[6] BUS[7] BUS[8] BUS[9] BUS[10]
+ BUS[11] BUS[12] BUS[13] BUS[14] BUS[15] BUS[16] BUS[17] BUS[18] BUS[19] BUS[20] BUS[21] BUS[22] BUS[23] BUS[24] BUS[25] PIN[8] VDDd VSSd
+ enable Q_out[169] Q_out[170] Q_out[171] Q_out[172] Q_out[173] Q_out[174] Q_out[175] Q_out[176] Q_out[177] Q_out[178] Q_out[179]
+ Q_out[180] Q_out[181] Q_out[182] Q_out[183] Q_out[184] Q_out[185] Q_out[186] Q_out[187] Q_out[188] Q_out[189] Q_out[190] Q_out[191]
+ Q_out[192] swmatrix_row_25_w_clkbuf
xswmatrix_row[9] D_out_row[8] D_out_row[9] PHI_1 PHI_2 BUS[1] BUS[2] BUS[3] BUS[4] BUS[5] BUS[6] BUS[7] BUS[8] BUS[9] BUS[10]
+ BUS[11] BUS[12] BUS[13] BUS[14] BUS[15] BUS[16] BUS[17] BUS[18] BUS[19] BUS[20] BUS[21] BUS[22] BUS[23] BUS[24] BUS[25] PIN[9] VDDd VSSd
+ enable Q_out[193] Q_out[194] Q_out[195] Q_out[196] Q_out[197] Q_out[198] Q_out[199] Q_out[200] Q_out[201] Q_out[202] Q_out[203]
+ Q_out[204] Q_out[205] Q_out[206] Q_out[207] Q_out[208] Q_out[209] Q_out[210] Q_out[211] Q_out[212] Q_out[213] Q_out[214] Q_out[215]
+ Q_out[216] swmatrix_row_25_w_clkbuf
xswmatrix_row[10] D_out_row[9] D_out_row[10] PHI_1 PHI_2 BUS[1] BUS[2] BUS[3] BUS[4] BUS[5] BUS[6] BUS[7] BUS[8] BUS[9] BUS[10]
+ BUS[11] BUS[12] BUS[13] BUS[14] BUS[15] BUS[16] BUS[17] BUS[18] BUS[19] BUS[20] BUS[21] BUS[22] BUS[23] BUS[24] BUS[25] PIN[10] VDDd VSSd
+ enable Q_out[217] Q_out[218] Q_out[219] Q_out[220] Q_out[221] Q_out[222] Q_out[223] Q_out[224] Q_out[225] Q_out[226] Q_out[227]
+ Q_out[228] Q_out[229] Q_out[230] Q_out[231] Q_out[232] Q_out[233] Q_out[234] Q_out[235] Q_out[236] Q_out[237] Q_out[238] Q_out[239]
+ Q_out[240] swmatrix_row_25_w_clkbuf
xswmatrix_row[11] D_out_row[10] D_out_row[11] PHI_1 PHI_2 BUS[1] BUS[2] BUS[3] BUS[4] BUS[5] BUS[6] BUS[7] BUS[8] BUS[9] BUS[10]
+ BUS[11] BUS[12] BUS[13] BUS[14] BUS[15] BUS[16] BUS[17] BUS[18] BUS[19] BUS[20] BUS[21] BUS[22] BUS[23] BUS[24] BUS[25] PIN[11] VDDd VSSd
+ enable Q_out[241] Q_out[242] Q_out[243] Q_out[244] Q_out[245] Q_out[246] Q_out[247] Q_out[248] Q_out[249] Q_out[250] Q_out[251]
+ Q_out[252] Q_out[253] Q_out[254] Q_out[255] Q_out[256] Q_out[257] Q_out[258] Q_out[259] Q_out[260] Q_out[261] Q_out[262] Q_out[263]
+ Q_out[264] swmatrix_row_25_w_clkbuf
xswmatrix_row[12] D_out_row[11] D_out_row[12] PHI_1 PHI_2 BUS[1] BUS[2] BUS[3] BUS[4] BUS[5] BUS[6] BUS[7] BUS[8] BUS[9] BUS[10]
+ BUS[11] BUS[12] BUS[13] BUS[14] BUS[15] BUS[16] BUS[17] BUS[18] BUS[19] BUS[20] BUS[21] BUS[22] BUS[23] BUS[24] BUS[25] PIN[12] VDDd VSSd
+ enable Q_out[265] Q_out[266] Q_out[267] Q_out[268] Q_out[269] Q_out[270] Q_out[271] Q_out[272] Q_out[273] Q_out[274] Q_out[275]
+ Q_out[276] Q_out[277] Q_out[278] Q_out[279] Q_out[280] Q_out[281] Q_out[282] Q_out[283] Q_out[284] Q_out[285] Q_out[286] Q_out[287]
+ Q_out[288] swmatrix_row_25_w_clkbuf
xswmatrix_row[13] D_out_row[12] D_out_row[13] PHI_1 PHI_2 BUS[1] BUS[2] BUS[3] BUS[4] BUS[5] BUS[6] BUS[7] BUS[8] BUS[9] BUS[10]
+ BUS[11] BUS[12] BUS[13] BUS[14] BUS[15] BUS[16] BUS[17] BUS[18] BUS[19] BUS[20] BUS[21] BUS[22] BUS[23] BUS[24] BUS[25] PIN[13] VDDd VSSd
+ enable Q_out[289] Q_out[290] Q_out[291] Q_out[292] Q_out[293] Q_out[294] Q_out[295] Q_out[296] Q_out[297] Q_out[298] Q_out[299]
+ Q_out[300] Q_out[301] Q_out[302] Q_out[303] Q_out[304] Q_out[305] Q_out[306] Q_out[307] Q_out[308] Q_out[309] Q_out[310] Q_out[311]
+ Q_out[312] swmatrix_row_25_w_clkbuf
xswmatrix_row[14] D_out_row[13] D_out_row[14] PHI_1 PHI_2 BUS[1] BUS[2] BUS[3] BUS[4] BUS[5] BUS[6] BUS[7] BUS[8] BUS[9] BUS[10]
+ BUS[11] BUS[12] BUS[13] BUS[14] BUS[15] BUS[16] BUS[17] BUS[18] BUS[19] BUS[20] BUS[21] BUS[22] BUS[23] BUS[24] BUS[25] PIN[14] VDDd VSSd
+ enable Q_out[313] Q_out[314] Q_out[315] Q_out[316] Q_out[317] Q_out[318] Q_out[319] Q_out[320] Q_out[321] Q_out[322] Q_out[323]
+ Q_out[324] Q_out[325] Q_out[326] Q_out[327] Q_out[328] Q_out[329] Q_out[330] Q_out[331] Q_out[332] Q_out[333] Q_out[334] Q_out[335]
+ Q_out[336] swmatrix_row_25_w_clkbuf
xswmatrix_row[15] D_out_row[14] D_out_row[15] PHI_1 PHI_2 BUS[1] BUS[2] BUS[3] BUS[4] BUS[5] BUS[6] BUS[7] BUS[8] BUS[9] BUS[10]
+ BUS[11] BUS[12] BUS[13] BUS[14] BUS[15] BUS[16] BUS[17] BUS[18] BUS[19] BUS[20] BUS[21] BUS[22] BUS[23] BUS[24] BUS[25] PIN[15] VDDd VSSd
+ enable Q_out[337] Q_out[338] Q_out[339] Q_out[340] Q_out[341] Q_out[342] Q_out[343] Q_out[344] Q_out[345] Q_out[346] Q_out[347]
+ Q_out[348] Q_out[349] Q_out[350] Q_out[351] Q_out[352] Q_out[353] Q_out[354] Q_out[355] Q_out[356] Q_out[357] Q_out[358] Q_out[359]
+ Q_out[360] swmatrix_row_25_w_clkbuf
xswmatrix_row[16] D_out_row[15] D_out_row[16] PHI_1 PHI_2 BUS[1] BUS[2] BUS[3] BUS[4] BUS[5] BUS[6] BUS[7] BUS[8] BUS[9] BUS[10]
+ BUS[11] BUS[12] BUS[13] BUS[14] BUS[15] BUS[16] BUS[17] BUS[18] BUS[19] BUS[20] BUS[21] BUS[22] BUS[23] BUS[24] BUS[25] PIN[16] VDDd VSSd
+ enable Q_out[361] Q_out[362] Q_out[363] Q_out[364] Q_out[365] Q_out[366] Q_out[367] Q_out[368] Q_out[369] Q_out[370] Q_out[371]
+ Q_out[372] Q_out[373] Q_out[374] Q_out[375] Q_out[376] Q_out[377] Q_out[378] Q_out[379] Q_out[380] Q_out[381] Q_out[382] Q_out[383]
+ Q_out[384] swmatrix_row_25_w_clkbuf
xswmatrix_row[17] D_out_row[16] D_out_row[17] PHI_1 PHI_2 BUS[1] BUS[2] BUS[3] BUS[4] BUS[5] BUS[6] BUS[7] BUS[8] BUS[9] BUS[10]
+ BUS[11] BUS[12] BUS[13] BUS[14] BUS[15] BUS[16] BUS[17] BUS[18] BUS[19] BUS[20] BUS[21] BUS[22] BUS[23] BUS[24] BUS[25] PIN[17] VDDd VSSd
+ enable Q_out[385] Q_out[386] Q_out[387] Q_out[388] Q_out[389] Q_out[390] Q_out[391] Q_out[392] Q_out[393] Q_out[394] Q_out[395]
+ Q_out[396] Q_out[397] Q_out[398] Q_out[399] Q_out[400] Q_out[401] Q_out[402] Q_out[403] Q_out[404] Q_out[405] Q_out[406] Q_out[407]
+ Q_out[408] swmatrix_row_25_w_clkbuf
xswmatrix_row[18] D_out_row[17] D_out_row[18] PHI_1 PHI_2 BUS[1] BUS[2] BUS[3] BUS[4] BUS[5] BUS[6] BUS[7] BUS[8] BUS[9] BUS[10]
+ BUS[11] BUS[12] BUS[13] BUS[14] BUS[15] BUS[16] BUS[17] BUS[18] BUS[19] BUS[20] BUS[21] BUS[22] BUS[23] BUS[24] BUS[25] PIN[18] VDDd VSSd
+ enable Q_out[409] Q_out[410] Q_out[411] Q_out[412] Q_out[413] Q_out[414] Q_out[415] Q_out[416] Q_out[417] Q_out[418] Q_out[419]
+ Q_out[420] Q_out[421] Q_out[422] Q_out[423] Q_out[424] Q_out[425] Q_out[426] Q_out[427] Q_out[428] Q_out[429] Q_out[430] Q_out[431]
+ Q_out[432] swmatrix_row_25_w_clkbuf
xswmatrix_row[19] D_out_row[18] D_out_row[19] PHI_1 PHI_2 BUS[1] BUS[2] BUS[3] BUS[4] BUS[5] BUS[6] BUS[7] BUS[8] BUS[9] BUS[10]
+ BUS[11] BUS[12] BUS[13] BUS[14] BUS[15] BUS[16] BUS[17] BUS[18] BUS[19] BUS[20] BUS[21] BUS[22] BUS[23] BUS[24] BUS[25] PIN[19] VDDd VSSd
+ enable Q_out[433] Q_out[434] Q_out[435] Q_out[436] Q_out[437] Q_out[438] Q_out[439] Q_out[440] Q_out[441] Q_out[442] Q_out[443]
+ Q_out[444] Q_out[445] Q_out[446] Q_out[447] Q_out[448] Q_out[449] Q_out[450] Q_out[451] Q_out[452] Q_out[453] Q_out[454] Q_out[455]
+ Q_out[456] swmatrix_row_25_w_clkbuf
xswmatrix_row[20] D_out_row[19] D_out_row[20] PHI_1 PHI_2 BUS[1] BUS[2] BUS[3] BUS[4] BUS[5] BUS[6] BUS[7] BUS[8] BUS[9] BUS[10]
+ BUS[11] BUS[12] BUS[13] BUS[14] BUS[15] BUS[16] BUS[17] BUS[18] BUS[19] BUS[20] BUS[21] BUS[22] BUS[23] BUS[24] BUS[25] PIN[20] VDDd VSSd
+ enable Q_out[457] Q_out[458] Q_out[459] Q_out[460] Q_out[461] Q_out[462] Q_out[463] Q_out[464] Q_out[465] Q_out[466] Q_out[467]
+ Q_out[468] Q_out[469] Q_out[470] Q_out[471] Q_out[472] Q_out[473] Q_out[474] Q_out[475] Q_out[476] Q_out[477] Q_out[478] Q_out[479]
+ Q_out[480] swmatrix_row_25_w_clkbuf
xswmatrix_row[21] D_out_row[20] D_out_row[21] PHI_1 PHI_2 BUS[1] BUS[2] BUS[3] BUS[4] BUS[5] BUS[6] BUS[7] BUS[8] BUS[9] BUS[10]
+ BUS[11] BUS[12] BUS[13] BUS[14] BUS[15] BUS[16] BUS[17] BUS[18] BUS[19] BUS[20] BUS[21] BUS[22] BUS[23] BUS[24] BUS[25] PIN[21] VDDd VSSd
+ enable Q_out[481] Q_out[482] Q_out[483] Q_out[484] Q_out[485] Q_out[486] Q_out[487] Q_out[488] Q_out[489] Q_out[490] Q_out[491]
+ Q_out[492] Q_out[493] Q_out[494] Q_out[495] Q_out[496] Q_out[497] Q_out[498] Q_out[499] Q_out[500] Q_out[501] Q_out[502] Q_out[503]
+ Q_out[504] swmatrix_row_25_w_clkbuf
xswmatrix_row[22] D_out_row[21] D_out_row[22] PHI_1 PHI_2 BUS[1] BUS[2] BUS[3] BUS[4] BUS[5] BUS[6] BUS[7] BUS[8] BUS[9] BUS[10]
+ BUS[11] BUS[12] BUS[13] BUS[14] BUS[15] BUS[16] BUS[17] BUS[18] BUS[19] BUS[20] BUS[21] BUS[22] BUS[23] BUS[24] BUS[25] PIN[22] VDDd VSSd
+ enable Q_out[505] Q_out[506] Q_out[507] Q_out[508] Q_out[509] Q_out[510] Q_out[511] Q_out[512] Q_out[513] Q_out[514] Q_out[515]
+ Q_out[516] Q_out[517] Q_out[518] Q_out[519] Q_out[520] Q_out[521] Q_out[522] Q_out[523] Q_out[524] Q_out[525] Q_out[526] Q_out[527]
+ Q_out[528] swmatrix_row_25_w_clkbuf
xswmatrix_row[23] D_out_row[22] D_out_row[23] PHI_1 PHI_2 BUS[1] BUS[2] BUS[3] BUS[4] BUS[5] BUS[6] BUS[7] BUS[8] BUS[9] BUS[10]
+ BUS[11] BUS[12] BUS[13] BUS[14] BUS[15] BUS[16] BUS[17] BUS[18] BUS[19] BUS[20] BUS[21] BUS[22] BUS[23] BUS[24] BUS[25] PIN[23] VDDd VSSd
+ enable Q_out[529] Q_out[530] Q_out[531] Q_out[532] Q_out[533] Q_out[534] Q_out[535] Q_out[536] Q_out[537] Q_out[538] Q_out[539]
+ Q_out[540] Q_out[541] Q_out[542] Q_out[543] Q_out[544] Q_out[545] Q_out[546] Q_out[547] Q_out[548] Q_out[549] Q_out[550] Q_out[551]
+ Q_out[552] swmatrix_row_25_w_clkbuf
xswmatrix_row[24] D_out_row[23] D_out_row[24] PHI_1 PHI_2 BUS[1] BUS[2] BUS[3] BUS[4] BUS[5] BUS[6] BUS[7] BUS[8] BUS[9] BUS[10]
+ BUS[11] BUS[12] BUS[13] BUS[14] BUS[15] BUS[16] BUS[17] BUS[18] BUS[19] BUS[20] BUS[21] BUS[22] BUS[23] BUS[24] BUS[25] PIN[24] VDDd VSSd
+ enable Q_out[553] Q_out[554] Q_out[555] Q_out[556] Q_out[557] Q_out[558] Q_out[559] Q_out[560] Q_out[561] Q_out[562] Q_out[563]
+ Q_out[564] Q_out[565] Q_out[566] Q_out[567] Q_out[568] Q_out[569] Q_out[570] Q_out[571] Q_out[572] Q_out[573] Q_out[574] Q_out[575]
+ Q_out[576] swmatrix_row_25_w_clkbuf
xswmatrix_row[25] D_out_row[24] D_out_row[25] PHI_1 PHI_2 BUS[1] BUS[2] BUS[3] BUS[4] BUS[5] BUS[6] BUS[7] BUS[8] BUS[9] BUS[10]
+ BUS[11] BUS[12] BUS[13] BUS[14] BUS[15] BUS[16] BUS[17] BUS[18] BUS[19] BUS[20] BUS[21] BUS[22] BUS[23] BUS[24] BUS[25] PIN[25] VDDd VSSd
+ enable Q_out[577] Q_out[578] Q_out[579] Q_out[580] Q_out[581] Q_out[582] Q_out[583] Q_out[584] Q_out[585] Q_out[586] Q_out[587]
+ Q_out[588] Q_out[589] Q_out[590] Q_out[591] Q_out[592] Q_out[593] Q_out[594] Q_out[595] Q_out[596] Q_out[597] Q_out[598] Q_out[599]
+ Q_out[600] swmatrix_row_25_w_clkbuf
xswmatrix_row[26] D_out_row[25] D_out_row[26] PHI_1 PHI_2 BUS[1] BUS[2] BUS[3] BUS[4] BUS[5] BUS[6] BUS[7] BUS[8] BUS[9] BUS[10]
+ BUS[11] BUS[12] BUS[13] BUS[14] BUS[15] BUS[16] BUS[17] BUS[18] BUS[19] BUS[20] BUS[21] BUS[22] BUS[23] BUS[24] BUS[25] PIN[26] VDDd VSSd
+ enable Q_out[601] Q_out[602] Q_out[603] Q_out[604] Q_out[605] Q_out[606] Q_out[607] Q_out[608] Q_out[609] Q_out[610] Q_out[611]
+ Q_out[612] Q_out[613] Q_out[614] Q_out[615] Q_out[616] Q_out[617] Q_out[618] Q_out[619] Q_out[620] Q_out[621] Q_out[622] Q_out[623]
+ Q_out[624] swmatrix_row_25_w_clkbuf
xswmatrix_row[27] D_out_row[26] D_out_row[27] PHI_1 PHI_2 BUS[1] BUS[2] BUS[3] BUS[4] BUS[5] BUS[6] BUS[7] BUS[8] BUS[9] BUS[10]
+ BUS[11] BUS[12] BUS[13] BUS[14] BUS[15] BUS[16] BUS[17] BUS[18] BUS[19] BUS[20] BUS[21] BUS[22] BUS[23] BUS[24] BUS[25] PIN[27] VDDd VSSd
+ enable Q_out[625] Q_out[626] Q_out[627] Q_out[628] Q_out[629] Q_out[630] Q_out[631] Q_out[632] Q_out[633] Q_out[634] Q_out[635]
+ Q_out[636] Q_out[637] Q_out[638] Q_out[639] Q_out[640] Q_out[641] Q_out[642] Q_out[643] Q_out[644] Q_out[645] Q_out[646] Q_out[647]
+ Q_out[648] swmatrix_row_25_w_clkbuf
xswmatrix_row[28] D_out_row[27] D_out_row[28] PHI_1 PHI_2 BUS[1] BUS[2] BUS[3] BUS[4] BUS[5] BUS[6] BUS[7] BUS[8] BUS[9] BUS[10]
+ BUS[11] BUS[12] BUS[13] BUS[14] BUS[15] BUS[16] BUS[17] BUS[18] BUS[19] BUS[20] BUS[21] BUS[22] BUS[23] BUS[24] BUS[25] PIN[28] VDDd VSSd
+ enable Q_out[649] Q_out[650] Q_out[651] Q_out[652] Q_out[653] Q_out[654] Q_out[655] Q_out[656] Q_out[657] Q_out[658] Q_out[659]
+ Q_out[660] Q_out[661] Q_out[662] Q_out[663] Q_out[664] Q_out[665] Q_out[666] Q_out[667] Q_out[668] Q_out[669] Q_out[670] Q_out[671]
+ Q_out[672] swmatrix_row_25_w_clkbuf
xswmatrix_row[29] D_out_row[28] D_out_row[29] PHI_1 PHI_2 BUS[1] BUS[2] BUS[3] BUS[4] BUS[5] BUS[6] BUS[7] BUS[8] BUS[9] BUS[10]
+ BUS[11] BUS[12] BUS[13] BUS[14] BUS[15] BUS[16] BUS[17] BUS[18] BUS[19] BUS[20] BUS[21] BUS[22] BUS[23] BUS[24] BUS[25] PIN[29] VDDd VSSd
+ enable Q_out[673] Q_out[674] Q_out[675] Q_out[676] Q_out[677] Q_out[678] Q_out[679] Q_out[680] Q_out[681] Q_out[682] Q_out[683]
+ Q_out[684] Q_out[685] Q_out[686] Q_out[687] Q_out[688] Q_out[689] Q_out[690] Q_out[691] Q_out[692] Q_out[693] Q_out[694] Q_out[695]
+ Q_out[696] swmatrix_row_25_w_clkbuf
xswmatrix_row[30] D_out_row[29] D_out_row[30] PHI_1 PHI_2 BUS[1] BUS[2] BUS[3] BUS[4] BUS[5] BUS[6] BUS[7] BUS[8] BUS[9] BUS[10]
+ BUS[11] BUS[12] BUS[13] BUS[14] BUS[15] BUS[16] BUS[17] BUS[18] BUS[19] BUS[20] BUS[21] BUS[22] BUS[23] BUS[24] BUS[25] PIN[30] VDDd VSSd
+ enable Q_out[697] Q_out[698] Q_out[699] Q_out[700] Q_out[701] Q_out[702] Q_out[703] Q_out[704] Q_out[705] Q_out[706] Q_out[707]
+ Q_out[708] Q_out[709] Q_out[710] Q_out[711] Q_out[712] Q_out[713] Q_out[714] Q_out[715] Q_out[716] Q_out[717] Q_out[718] Q_out[719]
+ Q_out[720] swmatrix_row_25_w_clkbuf
xswmatrix_row[31] D_out_row[30] D_out_row[31] PHI_1 PHI_2 BUS[1] BUS[2] BUS[3] BUS[4] BUS[5] BUS[6] BUS[7] BUS[8] BUS[9] BUS[10]
+ BUS[11] BUS[12] BUS[13] BUS[14] BUS[15] BUS[16] BUS[17] BUS[18] BUS[19] BUS[20] BUS[21] BUS[22] BUS[23] BUS[24] BUS[25] PIN[31] VDDd VSSd
+ enable Q_out[721] Q_out[722] Q_out[723] Q_out[724] Q_out[725] Q_out[726] Q_out[727] Q_out[728] Q_out[729] Q_out[730] Q_out[731]
+ Q_out[732] Q_out[733] Q_out[734] Q_out[735] Q_out[736] Q_out[737] Q_out[738] Q_out[739] Q_out[740] Q_out[741] Q_out[742] Q_out[743]
+ Q_out[744] swmatrix_row_25_w_clkbuf
xswmatrix_row[32] D_out_row[31] D_out_row[32] PHI_1 PHI_2 BUS[1] BUS[2] BUS[3] BUS[4] BUS[5] BUS[6] BUS[7] BUS[8] BUS[9] BUS[10]
+ BUS[11] BUS[12] BUS[13] BUS[14] BUS[15] BUS[16] BUS[17] BUS[18] BUS[19] BUS[20] BUS[21] BUS[22] BUS[23] BUS[24] BUS[25] PIN[32] VDDd VSSd
+ enable Q_out[745] Q_out[746] Q_out[747] Q_out[748] Q_out[749] Q_out[750] Q_out[751] Q_out[752] Q_out[753] Q_out[754] Q_out[755]
+ Q_out[756] Q_out[757] Q_out[758] Q_out[759] Q_out[760] Q_out[761] Q_out[762] Q_out[763] Q_out[764] Q_out[765] Q_out[766] Q_out[767]
+ Q_out[768] swmatrix_row_25_w_clkbuf
xswmatrix_row[33] D_out_row[32] D_out_row[33] PHI_1 PHI_2 BUS[1] BUS[2] BUS[3] BUS[4] BUS[5] BUS[6] BUS[7] BUS[8] BUS[9] BUS[10]
+ BUS[11] BUS[12] BUS[13] BUS[14] BUS[15] BUS[16] BUS[17] BUS[18] BUS[19] BUS[20] BUS[21] BUS[22] BUS[23] BUS[24] BUS[25] PIN[33] VDDd VSSd
+ enable Q_out[769] Q_out[770] Q_out[771] Q_out[772] Q_out[773] Q_out[774] Q_out[775] Q_out[776] Q_out[777] Q_out[778] Q_out[779]
+ Q_out[780] Q_out[781] Q_out[782] Q_out[783] Q_out[784] Q_out[785] Q_out[786] Q_out[787] Q_out[788] Q_out[789] Q_out[790] Q_out[791]
+ Q_out[792] swmatrix_row_25_w_clkbuf
xswmatrix_row[34] D_out_row[33] D_out_row[34] PHI_1 PHI_2 BUS[1] BUS[2] BUS[3] BUS[4] BUS[5] BUS[6] BUS[7] BUS[8] BUS[9] BUS[10]
+ BUS[11] BUS[12] BUS[13] BUS[14] BUS[15] BUS[16] BUS[17] BUS[18] BUS[19] BUS[20] BUS[21] BUS[22] BUS[23] BUS[24] BUS[25] PIN[34] VDDd VSSd
+ enable Q_out[793] Q_out[794] Q_out[795] Q_out[796] Q_out[797] Q_out[798] Q_out[799] Q_out[800] Q_out[801] Q_out[802] Q_out[803]
+ Q_out[804] Q_out[805] Q_out[806] Q_out[807] Q_out[808] Q_out[809] Q_out[810] Q_out[811] Q_out[812] Q_out[813] Q_out[814] Q_out[815]
+ Q_out[816] swmatrix_row_25_w_clkbuf
xswmatrix_row[35] D_out_row[34] D_out_row[35] PHI_1 PHI_2 BUS[1] BUS[2] BUS[3] BUS[4] BUS[5] BUS[6] BUS[7] BUS[8] BUS[9] BUS[10]
+ BUS[11] BUS[12] BUS[13] BUS[14] BUS[15] BUS[16] BUS[17] BUS[18] BUS[19] BUS[20] BUS[21] BUS[22] BUS[23] BUS[24] BUS[25] PIN[35] VDDd VSSd
+ enable Q_out[817] Q_out[818] Q_out[819] Q_out[820] Q_out[821] Q_out[822] Q_out[823] Q_out[824] Q_out[825] Q_out[826] Q_out[827]
+ Q_out[828] Q_out[829] Q_out[830] Q_out[831] Q_out[832] Q_out[833] Q_out[834] Q_out[835] Q_out[836] Q_out[837] Q_out[838] Q_out[839]
+ Q_out[840] swmatrix_row_25_w_clkbuf
xswmatrix_row[36] D_out_row[35] D_out_row[36] PHI_1 PHI_2 BUS[1] BUS[2] BUS[3] BUS[4] BUS[5] BUS[6] BUS[7] BUS[8] BUS[9] BUS[10]
+ BUS[11] BUS[12] BUS[13] BUS[14] BUS[15] BUS[16] BUS[17] BUS[18] BUS[19] BUS[20] BUS[21] BUS[22] BUS[23] BUS[24] BUS[25] PIN[36] VDDd VSSd
+ enable Q_out[841] Q_out[842] Q_out[843] Q_out[844] Q_out[845] Q_out[846] Q_out[847] Q_out[848] Q_out[849] Q_out[850] Q_out[851]
+ Q_out[852] Q_out[853] Q_out[854] Q_out[855] Q_out[856] Q_out[857] Q_out[858] Q_out[859] Q_out[860] Q_out[861] Q_out[862] Q_out[863]
+ Q_out[864] swmatrix_row_25_w_clkbuf
xswmatrix_row[37] D_out_row[36] D_out_row[37] PHI_1 PHI_2 BUS[1] BUS[2] BUS[3] BUS[4] BUS[5] BUS[6] BUS[7] BUS[8] BUS[9] BUS[10]
+ BUS[11] BUS[12] BUS[13] BUS[14] BUS[15] BUS[16] BUS[17] BUS[18] BUS[19] BUS[20] BUS[21] BUS[22] BUS[23] BUS[24] BUS[25] PIN[37] VDDd VSSd
+ enable Q_out[865] Q_out[866] Q_out[867] Q_out[868] Q_out[869] Q_out[870] Q_out[871] Q_out[872] Q_out[873] Q_out[874] Q_out[875]
+ Q_out[876] Q_out[877] Q_out[878] Q_out[879] Q_out[880] Q_out[881] Q_out[882] Q_out[883] Q_out[884] Q_out[885] Q_out[886] Q_out[887]
+ Q_out[888] swmatrix_row_25_w_clkbuf
xswmatrix_row[38] D_out_row[37] D_out_row[38] PHI_1 PHI_2 BUS[1] BUS[2] BUS[3] BUS[4] BUS[5] BUS[6] BUS[7] BUS[8] BUS[9] BUS[10]
+ BUS[11] BUS[12] BUS[13] BUS[14] BUS[15] BUS[16] BUS[17] BUS[18] BUS[19] BUS[20] BUS[21] BUS[22] BUS[23] BUS[24] BUS[25] PIN[38] VDDd VSSd
+ enable Q_out[889] Q_out[890] Q_out[891] Q_out[892] Q_out[893] Q_out[894] Q_out[895] Q_out[896] Q_out[897] Q_out[898] Q_out[899]
+ Q_out[900] Q_out[901] Q_out[902] Q_out[903] Q_out[904] Q_out[905] Q_out[906] Q_out[907] Q_out[908] Q_out[909] Q_out[910] Q_out[911]
+ Q_out[912] swmatrix_row_25_w_clkbuf
xswmatrix_row[39] D_out_row[38] D_out_row[39] PHI_1 PHI_2 BUS[1] BUS[2] BUS[3] BUS[4] BUS[5] BUS[6] BUS[7] BUS[8] BUS[9] BUS[10]
+ BUS[11] BUS[12] BUS[13] BUS[14] BUS[15] BUS[16] BUS[17] BUS[18] BUS[19] BUS[20] BUS[21] BUS[22] BUS[23] BUS[24] BUS[25] PIN[39] VDDd VSSd
+ enable Q_out[913] Q_out[914] Q_out[915] Q_out[916] Q_out[917] Q_out[918] Q_out[919] Q_out[920] Q_out[921] Q_out[922] Q_out[923]
+ Q_out[924] Q_out[925] Q_out[926] Q_out[927] Q_out[928] Q_out[929] Q_out[930] Q_out[931] Q_out[932] Q_out[933] Q_out[934] Q_out[935]
+ Q_out[936] swmatrix_row_25_w_clkbuf
xswmatrix_row[40] D_out_row[39] D_out_row[40] PHI_1 PHI_2 BUS[1] BUS[2] BUS[3] BUS[4] BUS[5] BUS[6] BUS[7] BUS[8] BUS[9] BUS[10]
+ BUS[11] BUS[12] BUS[13] BUS[14] BUS[15] BUS[16] BUS[17] BUS[18] BUS[19] BUS[20] BUS[21] BUS[22] BUS[23] BUS[24] BUS[25] PIN[40] VDDd VSSd
+ enable Q_out[937] Q_out[938] Q_out[939] Q_out[940] Q_out[941] Q_out[942] Q_out[943] Q_out[944] Q_out[945] Q_out[946] Q_out[947]
+ Q_out[948] Q_out[949] Q_out[950] Q_out[951] Q_out[952] Q_out[953] Q_out[954] Q_out[955] Q_out[956] Q_out[957] Q_out[958] Q_out[959]
+ Q_out[960] swmatrix_row_25_w_clkbuf
xswmatrix_row[41] D_out_row[40] D_out_row[41] PHI_1 PHI_2 BUS[1] BUS[2] BUS[3] BUS[4] BUS[5] BUS[6] BUS[7] BUS[8] BUS[9] BUS[10]
+ BUS[11] BUS[12] BUS[13] BUS[14] BUS[15] BUS[16] BUS[17] BUS[18] BUS[19] BUS[20] BUS[21] BUS[22] BUS[23] BUS[24] BUS[25] PIN[41] VDDd VSSd
+ enable Q_out[961] Q_out[962] Q_out[963] Q_out[964] Q_out[965] Q_out[966] Q_out[967] Q_out[968] Q_out[969] Q_out[970] Q_out[971]
+ Q_out[972] Q_out[973] Q_out[974] Q_out[975] Q_out[976] Q_out[977] Q_out[978] Q_out[979] Q_out[980] Q_out[981] Q_out[982] Q_out[983]
+ Q_out[984] swmatrix_row_25_w_clkbuf
xswmatrix_row[42] D_out_row[41] D_out_row[42] PHI_1 PHI_2 BUS[1] BUS[2] BUS[3] BUS[4] BUS[5] BUS[6] BUS[7] BUS[8] BUS[9] BUS[10]
+ BUS[11] BUS[12] BUS[13] BUS[14] BUS[15] BUS[16] BUS[17] BUS[18] BUS[19] BUS[20] BUS[21] BUS[22] BUS[23] BUS[24] BUS[25] PIN[42] VDDd VSSd
+ enable Q_out[985] Q_out[986] Q_out[987] Q_out[988] Q_out[989] Q_out[990] Q_out[991] Q_out[992] Q_out[993] Q_out[994] Q_out[995]
+ Q_out[996] Q_out[997] Q_out[998] Q_out[999] Q_out[1000] Q_out[1001] Q_out[1002] Q_out[1003] Q_out[1004] Q_out[1005] Q_out[1006] Q_out[1007]
+ Q_out[1008] swmatrix_row_25_w_clkbuf
xswmatrix_row[43] D_out_row[42] D_out_row[43] PHI_1 PHI_2 BUS[1] BUS[2] BUS[3] BUS[4] BUS[5] BUS[6] BUS[7] BUS[8] BUS[9] BUS[10]
+ BUS[11] BUS[12] BUS[13] BUS[14] BUS[15] BUS[16] BUS[17] BUS[18] BUS[19] BUS[20] BUS[21] BUS[22] BUS[23] BUS[24] BUS[25] PIN[43] VDDd VSSd
+ enable Q_out[1009] Q_out[1010] Q_out[1011] Q_out[1012] Q_out[1013] Q_out[1014] Q_out[1015] Q_out[1016] Q_out[1017] Q_out[1018]
+ Q_out[1019] Q_out[1020] Q_out[1021] Q_out[1022] Q_out[1023] Q_out[1024] Q_out[1025] Q_out[1026] Q_out[1027] Q_out[1028] Q_out[1029]
+ Q_out[1030] Q_out[1031] Q_out[1032] swmatrix_row_25_w_clkbuf
xswmatrix_row[44] D_out_row[43] D_out_row[44] PHI_1 PHI_2 BUS[1] BUS[2] BUS[3] BUS[4] BUS[5] BUS[6] BUS[7] BUS[8] BUS[9] BUS[10]
+ BUS[11] BUS[12] BUS[13] BUS[14] BUS[15] BUS[16] BUS[17] BUS[18] BUS[19] BUS[20] BUS[21] BUS[22] BUS[23] BUS[24] BUS[25] PIN[44] VDDd VSSd
+ enable Q_out[1033] Q_out[1034] Q_out[1035] Q_out[1036] Q_out[1037] Q_out[1038] Q_out[1039] Q_out[1040] Q_out[1041] Q_out[1042]
+ Q_out[1043] Q_out[1044] Q_out[1045] Q_out[1046] Q_out[1047] Q_out[1048] Q_out[1049] Q_out[1050] Q_out[1051] Q_out[1052] Q_out[1053]
+ Q_out[1054] Q_out[1055] Q_out[1056] swmatrix_row_25_w_clkbuf
xswmatrix_row[45] D_out_row[44] D_out_row[45] PHI_1 PHI_2 BUS[1] BUS[2] BUS[3] BUS[4] BUS[5] BUS[6] BUS[7] BUS[8] BUS[9] BUS[10]
+ BUS[11] BUS[12] BUS[13] BUS[14] BUS[15] BUS[16] BUS[17] BUS[18] BUS[19] BUS[20] BUS[21] BUS[22] BUS[23] BUS[24] BUS[25] PIN[45] VDDd VSSd
+ enable Q_out[1057] Q_out[1058] Q_out[1059] Q_out[1060] Q_out[1061] Q_out[1062] Q_out[1063] Q_out[1064] Q_out[1065] Q_out[1066]
+ Q_out[1067] Q_out[1068] Q_out[1069] Q_out[1070] Q_out[1071] Q_out[1072] Q_out[1073] Q_out[1074] Q_out[1075] Q_out[1076] Q_out[1077]
+ Q_out[1078] Q_out[1079] Q_out[1080] swmatrix_row_25_w_clkbuf
xswmatrix_row[46] D_out_row[45] D_out_row[46] PHI_1 PHI_2 BUS[1] BUS[2] BUS[3] BUS[4] BUS[5] BUS[6] BUS[7] BUS[8] BUS[9] BUS[10]
+ BUS[11] BUS[12] BUS[13] BUS[14] BUS[15] BUS[16] BUS[17] BUS[18] BUS[19] BUS[20] BUS[21] BUS[22] BUS[23] BUS[24] BUS[25] PIN[46] VDDd VSSd
+ enable Q_out[1081] Q_out[1082] Q_out[1083] Q_out[1084] Q_out[1085] Q_out[1086] Q_out[1087] Q_out[1088] Q_out[1089] Q_out[1090]
+ Q_out[1091] Q_out[1092] Q_out[1093] Q_out[1094] Q_out[1095] Q_out[1096] Q_out[1097] Q_out[1098] Q_out[1099] Q_out[1100] Q_out[1101]
+ Q_out[1102] Q_out[1103] Q_out[1104] swmatrix_row_25_w_clkbuf
xswmatrix_row[47] D_out_row[46] D_out_row[47] PHI_1 PHI_2 BUS[1] BUS[2] BUS[3] BUS[4] BUS[5] BUS[6] BUS[7] BUS[8] BUS[9] BUS[10]
+ BUS[11] BUS[12] BUS[13] BUS[14] BUS[15] BUS[16] BUS[17] BUS[18] BUS[19] BUS[20] BUS[21] BUS[22] BUS[23] BUS[24] BUS[25] PIN[47] VDDd VSSd
+ enable Q_out[1105] Q_out[1106] Q_out[1107] Q_out[1108] Q_out[1109] Q_out[1110] Q_out[1111] Q_out[1112] Q_out[1113] Q_out[1114]
+ Q_out[1115] Q_out[1116] Q_out[1117] Q_out[1118] Q_out[1119] Q_out[1120] Q_out[1121] Q_out[1122] Q_out[1123] Q_out[1124] Q_out[1125]
+ Q_out[1126] Q_out[1127] Q_out[1128] swmatrix_row_25_w_clkbuf
xswmatrix_row[48] D_out_row[47] D_out_row[48] PHI_1 PHI_2 BUS[1] BUS[2] BUS[3] BUS[4] BUS[5] BUS[6] BUS[7] BUS[8] BUS[9] BUS[10]
+ BUS[11] BUS[12] BUS[13] BUS[14] BUS[15] BUS[16] BUS[17] BUS[18] BUS[19] BUS[20] BUS[21] BUS[22] BUS[23] BUS[24] BUS[25] PIN[48] VDDd VSSd
+ enable Q_out[1129] Q_out[1130] Q_out[1131] Q_out[1132] Q_out[1133] Q_out[1134] Q_out[1135] Q_out[1136] Q_out[1137] Q_out[1138]
+ Q_out[1139] Q_out[1140] Q_out[1141] Q_out[1142] Q_out[1143] Q_out[1144] Q_out[1145] Q_out[1146] Q_out[1147] Q_out[1148] Q_out[1149]
+ Q_out[1150] Q_out[1151] Q_out[1152] swmatrix_row_25_w_clkbuf
xswmatrix_row[49] D_out_row[48] D_out_row[49] PHI_1 PHI_2 BUS[1] BUS[2] BUS[3] BUS[4] BUS[5] BUS[6] BUS[7] BUS[8] BUS[9] BUS[10]
+ BUS[11] BUS[12] BUS[13] BUS[14] BUS[15] BUS[16] BUS[17] BUS[18] BUS[19] BUS[20] BUS[21] BUS[22] BUS[23] BUS[24] BUS[25] PIN[49] VDDd VSSd
+ enable Q_out[1153] Q_out[1154] Q_out[1155] Q_out[1156] Q_out[1157] Q_out[1158] Q_out[1159] Q_out[1160] Q_out[1161] Q_out[1162]
+ Q_out[1163] Q_out[1164] Q_out[1165] Q_out[1166] Q_out[1167] Q_out[1168] Q_out[1169] Q_out[1170] Q_out[1171] Q_out[1172] Q_out[1173]
+ Q_out[1174] Q_out[1175] Q_out[1176] swmatrix_row_25_w_clkbuf
xswmatrix_row[50] D_out_row[49] D_out_row[50] PHI_1 PHI_2 BUS[1] BUS[2] BUS[3] BUS[4] BUS[5] BUS[6] BUS[7] BUS[8] BUS[9] BUS[10]
+ BUS[11] BUS[12] BUS[13] BUS[14] BUS[15] BUS[16] BUS[17] BUS[18] BUS[19] BUS[20] BUS[21] BUS[22] BUS[23] BUS[24] BUS[25] PIN[50] VDDd VSSd
+ enable Q_out[1177] Q_out[1178] Q_out[1179] Q_out[1180] Q_out[1181] Q_out[1182] Q_out[1183] Q_out[1184] Q_out[1185] Q_out[1186]
+ Q_out[1187] Q_out[1188] Q_out[1189] Q_out[1190] Q_out[1191] Q_out[1192] Q_out[1193] Q_out[1194] Q_out[1195] Q_out[1196] Q_out[1197]
+ Q_out[1198] Q_out[1199] Q_out[1200] swmatrix_row_25_w_clkbuf
xswmatrix_row[51] D_out_row[50] D_out_row[51] PHI_1 PHI_2 BUS[1] BUS[2] BUS[3] BUS[4] BUS[5] BUS[6] BUS[7] BUS[8] BUS[9] BUS[10]
+ BUS[11] BUS[12] BUS[13] BUS[14] BUS[15] BUS[16] BUS[17] BUS[18] BUS[19] BUS[20] BUS[21] BUS[22] BUS[23] BUS[24] BUS[25] PIN[51] VDDd VSSd
+ enable Q_out[1201] Q_out[1202] Q_out[1203] Q_out[1204] Q_out[1205] Q_out[1206] Q_out[1207] Q_out[1208] Q_out[1209] Q_out[1210]
+ Q_out[1211] Q_out[1212] Q_out[1213] Q_out[1214] Q_out[1215] Q_out[1216] Q_out[1217] Q_out[1218] Q_out[1219] Q_out[1220] Q_out[1221]
+ Q_out[1222] Q_out[1223] Q_out[1224] swmatrix_row_25_w_clkbuf
xswmatrix_row[52] D_out_row[51] D_out_row[52] PHI_1 PHI_2 BUS[1] BUS[2] BUS[3] BUS[4] BUS[5] BUS[6] BUS[7] BUS[8] BUS[9] BUS[10]
+ BUS[11] BUS[12] BUS[13] BUS[14] BUS[15] BUS[16] BUS[17] BUS[18] BUS[19] BUS[20] BUS[21] BUS[22] BUS[23] BUS[24] BUS[25] PIN[52] VDDd VSSd
+ enable Q_out[1225] Q_out[1226] Q_out[1227] Q_out[1228] Q_out[1229] Q_out[1230] Q_out[1231] Q_out[1232] Q_out[1233] Q_out[1234]
+ Q_out[1235] Q_out[1236] Q_out[1237] Q_out[1238] Q_out[1239] Q_out[1240] Q_out[1241] Q_out[1242] Q_out[1243] Q_out[1244] Q_out[1245]
+ Q_out[1246] Q_out[1247] Q_out[1248] swmatrix_row_25_w_clkbuf
xswmatrix_row[53] D_out_row[52] D_out_row[53] PHI_1 PHI_2 BUS[1] BUS[2] BUS[3] BUS[4] BUS[5] BUS[6] BUS[7] BUS[8] BUS[9] BUS[10]
+ BUS[11] BUS[12] BUS[13] BUS[14] BUS[15] BUS[16] BUS[17] BUS[18] BUS[19] BUS[20] BUS[21] BUS[22] BUS[23] BUS[24] BUS[25] PIN[53] VDDd VSSd
+ enable Q_out[1249] Q_out[1250] Q_out[1251] Q_out[1252] Q_out[1253] Q_out[1254] Q_out[1255] Q_out[1256] Q_out[1257] Q_out[1258]
+ Q_out[1259] Q_out[1260] Q_out[1261] Q_out[1262] Q_out[1263] Q_out[1264] Q_out[1265] Q_out[1266] Q_out[1267] Q_out[1268] Q_out[1269]
+ Q_out[1270] Q_out[1271] Q_out[1272] swmatrix_row_25_w_clkbuf
xswmatrix_row[54] D_out_row[53] D_out_row[54] PHI_1 PHI_2 BUS[1] BUS[2] BUS[3] BUS[4] BUS[5] BUS[6] BUS[7] BUS[8] BUS[9] BUS[10]
+ BUS[11] BUS[12] BUS[13] BUS[14] BUS[15] BUS[16] BUS[17] BUS[18] BUS[19] BUS[20] BUS[21] BUS[22] BUS[23] BUS[24] BUS[25] PIN[54] VDDd VSSd
+ enable Q_out[1273] Q_out[1274] Q_out[1275] Q_out[1276] Q_out[1277] Q_out[1278] Q_out[1279] Q_out[1280] Q_out[1281] Q_out[1282]
+ Q_out[1283] Q_out[1284] Q_out[1285] Q_out[1286] Q_out[1287] Q_out[1288] Q_out[1289] Q_out[1290] Q_out[1291] Q_out[1292] Q_out[1293]
+ Q_out[1294] Q_out[1295] Q_out[1296] swmatrix_row_25_w_clkbuf
xswmatrix_row[55] D_out_row[54] D_out_row[55] PHI_1 PHI_2 BUS[1] BUS[2] BUS[3] BUS[4] BUS[5] BUS[6] BUS[7] BUS[8] BUS[9] BUS[10]
+ BUS[11] BUS[12] BUS[13] BUS[14] BUS[15] BUS[16] BUS[17] BUS[18] BUS[19] BUS[20] BUS[21] BUS[22] BUS[23] BUS[24] BUS[25] PIN[55] VDDd VSSd
+ enable Q_out[1297] Q_out[1298] Q_out[1299] Q_out[1300] Q_out[1301] Q_out[1302] Q_out[1303] Q_out[1304] Q_out[1305] Q_out[1306]
+ Q_out[1307] Q_out[1308] Q_out[1309] Q_out[1310] Q_out[1311] Q_out[1312] Q_out[1313] Q_out[1314] Q_out[1315] Q_out[1316] Q_out[1317]
+ Q_out[1318] Q_out[1319] Q_out[1320] swmatrix_row_25_w_clkbuf
xswmatrix_row[56] D_out_row[55] D_out_row[56] PHI_1 PHI_2 BUS[1] BUS[2] BUS[3] BUS[4] BUS[5] BUS[6] BUS[7] BUS[8] BUS[9] BUS[10]
+ BUS[11] BUS[12] BUS[13] BUS[14] BUS[15] BUS[16] BUS[17] BUS[18] BUS[19] BUS[20] BUS[21] BUS[22] BUS[23] BUS[24] BUS[25] PIN[56] VDDd VSSd
+ enable Q_out[1321] Q_out[1322] Q_out[1323] Q_out[1324] Q_out[1325] Q_out[1326] Q_out[1327] Q_out[1328] Q_out[1329] Q_out[1330]
+ Q_out[1331] Q_out[1332] Q_out[1333] Q_out[1334] Q_out[1335] Q_out[1336] Q_out[1337] Q_out[1338] Q_out[1339] Q_out[1340] Q_out[1341]
+ Q_out[1342] Q_out[1343] Q_out[1344] swmatrix_row_25_w_clkbuf
xswmatrix_row[57] D_out_row[56] D_out_row[57] PHI_1 PHI_2 BUS[1] BUS[2] BUS[3] BUS[4] BUS[5] BUS[6] BUS[7] BUS[8] BUS[9] BUS[10]
+ BUS[11] BUS[12] BUS[13] BUS[14] BUS[15] BUS[16] BUS[17] BUS[18] BUS[19] BUS[20] BUS[21] BUS[22] BUS[23] BUS[24] BUS[25] PIN[57] VDDd VSSd
+ enable Q_out[1345] Q_out[1346] Q_out[1347] Q_out[1348] Q_out[1349] Q_out[1350] Q_out[1351] Q_out[1352] Q_out[1353] Q_out[1354]
+ Q_out[1355] Q_out[1356] Q_out[1357] Q_out[1358] Q_out[1359] Q_out[1360] Q_out[1361] Q_out[1362] Q_out[1363] Q_out[1364] Q_out[1365]
+ Q_out[1366] Q_out[1367] Q_out[1368] swmatrix_row_25_w_clkbuf
xswmatrix_row[58] D_out_row[57] D_out_row[58] PHI_1 PHI_2 BUS[1] BUS[2] BUS[3] BUS[4] BUS[5] BUS[6] BUS[7] BUS[8] BUS[9] BUS[10]
+ BUS[11] BUS[12] BUS[13] BUS[14] BUS[15] BUS[16] BUS[17] BUS[18] BUS[19] BUS[20] BUS[21] BUS[22] BUS[23] BUS[24] BUS[25] PIN[58] VDDd VSSd
+ enable Q_out[1369] Q_out[1370] Q_out[1371] Q_out[1372] Q_out[1373] Q_out[1374] Q_out[1375] Q_out[1376] Q_out[1377] Q_out[1378]
+ Q_out[1379] Q_out[1380] Q_out[1381] Q_out[1382] Q_out[1383] Q_out[1384] Q_out[1385] Q_out[1386] Q_out[1387] Q_out[1388] Q_out[1389]
+ Q_out[1390] Q_out[1391] Q_out[1392] swmatrix_row_25_w_clkbuf
xswmatrix_row[59] D_out_row[58] D_out_row[59] PHI_1 PHI_2 BUS[1] BUS[2] BUS[3] BUS[4] BUS[5] BUS[6] BUS[7] BUS[8] BUS[9] BUS[10]
+ BUS[11] BUS[12] BUS[13] BUS[14] BUS[15] BUS[16] BUS[17] BUS[18] BUS[19] BUS[20] BUS[21] BUS[22] BUS[23] BUS[24] BUS[25] PIN[59] VDDd VSSd
+ enable Q_out[1393] Q_out[1394] Q_out[1395] Q_out[1396] Q_out[1397] Q_out[1398] Q_out[1399] Q_out[1400] Q_out[1401] Q_out[1402]
+ Q_out[1403] Q_out[1404] Q_out[1405] Q_out[1406] Q_out[1407] Q_out[1408] Q_out[1409] Q_out[1410] Q_out[1411] Q_out[1412] Q_out[1413]
+ Q_out[1414] Q_out[1415] Q_out[1416] swmatrix_row_25_w_clkbuf
xswmatrix_row[60] D_out_row[59] D_out_row[60] PHI_1 PHI_2 BUS[1] BUS[2] BUS[3] BUS[4] BUS[5] BUS[6] BUS[7] BUS[8] BUS[9] BUS[10]
+ BUS[11] BUS[12] BUS[13] BUS[14] BUS[15] BUS[16] BUS[17] BUS[18] BUS[19] BUS[20] BUS[21] BUS[22] BUS[23] BUS[24] BUS[25] PIN[60] VDDd VSSd
+ enable Q_out[1417] Q_out[1418] Q_out[1419] Q_out[1420] Q_out[1421] Q_out[1422] Q_out[1423] Q_out[1424] Q_out[1425] Q_out[1426]
+ Q_out[1427] Q_out[1428] Q_out[1429] Q_out[1430] Q_out[1431] Q_out[1432] Q_out[1433] Q_out[1434] Q_out[1435] Q_out[1436] Q_out[1437]
+ Q_out[1438] Q_out[1439] Q_out[1440] swmatrix_row_25_w_clkbuf
xswmatrix_row[61] D_out_row[60] D_out_row[61] PHI_1 PHI_2 BUS[1] BUS[2] BUS[3] BUS[4] BUS[5] BUS[6] BUS[7] BUS[8] BUS[9] BUS[10]
+ BUS[11] BUS[12] BUS[13] BUS[14] BUS[15] BUS[16] BUS[17] BUS[18] BUS[19] BUS[20] BUS[21] BUS[22] BUS[23] BUS[24] BUS[25] PIN[61] VDDd VSSd
+ enable Q_out[1441] Q_out[1442] Q_out[1443] Q_out[1444] Q_out[1445] Q_out[1446] Q_out[1447] Q_out[1448] Q_out[1449] Q_out[1450]
+ Q_out[1451] Q_out[1452] Q_out[1453] Q_out[1454] Q_out[1455] Q_out[1456] Q_out[1457] Q_out[1458] Q_out[1459] Q_out[1460] Q_out[1461]
+ Q_out[1462] Q_out[1463] Q_out[1464] swmatrix_row_25_w_clkbuf
xswmatrix_row[62] D_out_row[61] D_out_row[62] PHI_1 PHI_2 BUS[1] BUS[2] BUS[3] BUS[4] BUS[5] BUS[6] BUS[7] BUS[8] BUS[9] BUS[10]
+ BUS[11] BUS[12] BUS[13] BUS[14] BUS[15] BUS[16] BUS[17] BUS[18] BUS[19] BUS[20] BUS[21] BUS[22] BUS[23] BUS[24] BUS[25] PIN[62] VDDd VSSd
+ enable Q_out[1465] Q_out[1466] Q_out[1467] Q_out[1468] Q_out[1469] Q_out[1470] Q_out[1471] Q_out[1472] Q_out[1473] Q_out[1474]
+ Q_out[1475] Q_out[1476] Q_out[1477] Q_out[1478] Q_out[1479] Q_out[1480] Q_out[1481] Q_out[1482] Q_out[1483] Q_out[1484] Q_out[1485]
+ Q_out[1486] Q_out[1487] Q_out[1488] swmatrix_row_25_w_clkbuf
xswmatrix_row[63] D_out_row[62] D_out_row[63] PHI_1 PHI_2 BUS[1] BUS[2] BUS[3] BUS[4] BUS[5] BUS[6] BUS[7] BUS[8] BUS[9] BUS[10]
+ BUS[11] BUS[12] BUS[13] BUS[14] BUS[15] BUS[16] BUS[17] BUS[18] BUS[19] BUS[20] BUS[21] BUS[22] BUS[23] BUS[24] BUS[25] PIN[63] VDDd VSSd
+ enable Q_out[1489] Q_out[1490] Q_out[1491] Q_out[1492] Q_out[1493] Q_out[1494] Q_out[1495] Q_out[1496] Q_out[1497] Q_out[1498]
+ Q_out[1499] Q_out[1500] Q_out[1501] Q_out[1502] Q_out[1503] Q_out[1504] Q_out[1505] Q_out[1506] Q_out[1507] Q_out[1508] Q_out[1509]
+ Q_out[1510] Q_out[1511] Q_out[1512] swmatrix_row_25_w_clkbuf
xswmatrix_row[64] D_out_row[63] D_out_row[64] PHI_1 PHI_2 BUS[1] BUS[2] BUS[3] BUS[4] BUS[5] BUS[6] BUS[7] BUS[8] BUS[9] BUS[10]
+ BUS[11] BUS[12] BUS[13] BUS[14] BUS[15] BUS[16] BUS[17] BUS[18] BUS[19] BUS[20] BUS[21] BUS[22] BUS[23] BUS[24] BUS[25] PIN[64] VDDd VSSd
+ enable Q_out[1513] Q_out[1514] Q_out[1515] Q_out[1516] Q_out[1517] Q_out[1518] Q_out[1519] Q_out[1520] Q_out[1521] Q_out[1522]
+ Q_out[1523] Q_out[1524] Q_out[1525] Q_out[1526] Q_out[1527] Q_out[1528] Q_out[1529] Q_out[1530] Q_out[1531] Q_out[1532] Q_out[1533]
+ Q_out[1534] Q_out[1535] Q_out[1536] swmatrix_row_25_w_clkbuf
xswmatrix_row[65] D_out_row[64] D_out_row[65] PHI_1 PHI_2 BUS[1] BUS[2] BUS[3] BUS[4] BUS[5] BUS[6] BUS[7] BUS[8] BUS[9] BUS[10]
+ BUS[11] BUS[12] BUS[13] BUS[14] BUS[15] BUS[16] BUS[17] BUS[18] BUS[19] BUS[20] BUS[21] BUS[22] BUS[23] BUS[24] BUS[25] PIN[65] VDDd VSSd
+ enable Q_out[1537] Q_out[1538] Q_out[1539] Q_out[1540] Q_out[1541] Q_out[1542] Q_out[1543] Q_out[1544] Q_out[1545] Q_out[1546]
+ Q_out[1547] Q_out[1548] Q_out[1549] Q_out[1550] Q_out[1551] Q_out[1552] Q_out[1553] Q_out[1554] Q_out[1555] Q_out[1556] Q_out[1557]
+ Q_out[1558] Q_out[1559] Q_out[1560] swmatrix_row_25_w_clkbuf
xswmatrix_row[66] D_out_row[65] D_out_row[66] PHI_1 PHI_2 BUS[1] BUS[2] BUS[3] BUS[4] BUS[5] BUS[6] BUS[7] BUS[8] BUS[9] BUS[10]
+ BUS[11] BUS[12] BUS[13] BUS[14] BUS[15] BUS[16] BUS[17] BUS[18] BUS[19] BUS[20] BUS[21] BUS[22] BUS[23] BUS[24] BUS[25] PIN[66] VDDd VSSd
+ enable Q_out[1561] Q_out[1562] Q_out[1563] Q_out[1564] Q_out[1565] Q_out[1566] Q_out[1567] Q_out[1568] Q_out[1569] Q_out[1570]
+ Q_out[1571] Q_out[1572] Q_out[1573] Q_out[1574] Q_out[1575] Q_out[1576] Q_out[1577] Q_out[1578] Q_out[1579] Q_out[1580] Q_out[1581]
+ Q_out[1582] Q_out[1583] Q_out[1584] swmatrix_row_25_w_clkbuf
xswmatrix_row[67] D_out_row[66] D_out_row[67] PHI_1 PHI_2 BUS[1] BUS[2] BUS[3] BUS[4] BUS[5] BUS[6] BUS[7] BUS[8] BUS[9] BUS[10]
+ BUS[11] BUS[12] BUS[13] BUS[14] BUS[15] BUS[16] BUS[17] BUS[18] BUS[19] BUS[20] BUS[21] BUS[22] BUS[23] BUS[24] BUS[25] PIN[67] VDDd VSSd
+ enable Q_out[1585] Q_out[1586] Q_out[1587] Q_out[1588] Q_out[1589] Q_out[1590] Q_out[1591] Q_out[1592] Q_out[1593] Q_out[1594]
+ Q_out[1595] Q_out[1596] Q_out[1597] Q_out[1598] Q_out[1599] Q_out[1600] Q_out[1601] Q_out[1602] Q_out[1603] Q_out[1604] Q_out[1605]
+ Q_out[1606] Q_out[1607] Q_out[1608] swmatrix_row_25_w_clkbuf
xswmatrix_row[68] D_out_row[67] D_out PHI_1 PHI_2 BUS[1] BUS[2] BUS[3] BUS[4] BUS[5] BUS[6] BUS[7] BUS[8] BUS[9] BUS[10] BUS[11]
+ BUS[12] BUS[13] BUS[14] BUS[15] BUS[16] BUS[17] BUS[18] BUS[19] BUS[20] BUS[21] BUS[22] BUS[23] BUS[24] BUS[25] PIN[68] VDDd VSSd enable
+ Q_out[1609] Q_out[1610] Q_out[1611] Q_out[1612] Q_out[1613] Q_out[1614] Q_out[1615] Q_out[1616] Q_out[1617] Q_out[1618] Q_out[1619]
+ Q_out[1620] Q_out[1621] Q_out[1622] Q_out[1623] Q_out[1624] Q_out[1625] Q_out[1626] Q_out[1627] Q_out[1628] Q_out[1629] Q_out[1630]
+ Q_out[1631] Q_out[1632] swmatrix_row_25_w_clkbuf
.ends

* expanding   symbol:  switch_matrix_gf180mcu_9t5v0/swmatrix_row_25/swmatrix_row_25_w_clkbuf.sym # of pins=10
** sym_path: /foss/designs/libs/switch_matrix_gf180mcu_9t5v0/swmatrix_row_25/swmatrix_row_25_w_clkbuf.sym
** sch_path: /foss/designs/libs/switch_matrix_gf180mcu_9t5v0/swmatrix_row_25/swmatrix_row_25_w_clkbuf.sch
.subckt swmatrix_row_25_w_clkbuf D_in D_out PHI_1 PHI_2 BUS[1] BUS[2] BUS[3] BUS[4] BUS[5] BUS[6] BUS[7] BUS[8] BUS[9] BUS[10]
+ BUS[11] BUS[12] BUS[13] BUS[14] BUS[15] BUS[16] BUS[17] BUS[18] BUS[19] BUS[20] BUS[21] BUS[22] BUS[23] BUS[24] BUS[25] pin VDDd VSSd
+ enable Q[1] Q[2] Q[3] Q[4] Q[5] Q[6] Q[7] Q[8] Q[9] Q[10] Q[11] Q[12] Q[13] Q[14] Q[15] Q[16] Q[17] Q[18] Q[19] Q[20] Q[21] Q[22] Q[23]
+ Q[24]
*.PININFO pin:B PHI_2:I PHI_1:I BUS[1:25]:B D_in:I Q[1:24]:B VDDd:B VSSd:B D_out:O enable:I
xSR Q[1] Q[2] Q[3] Q[4] Q[5] Q[6] Q[7] Q[8] Q[9] Q[10] Q[11] Q[12] Q[13] Q[14] Q[15] Q[16] Q[17] Q[18] Q[19] Q[20] Q[21] Q[22]
+ Q[23] Q[24] D_out D_in PHI_1_buf PHI_2_buf VDDd VSSd ShiftReg_row_25
xTgates[1] Q[1] BUS[1] pin VDDd VSSd enable_buf swmatrix_Tgate
xTgates[2] Q[2] BUS[2] pin VDDd VSSd enable_buf swmatrix_Tgate
xTgates[3] Q[3] BUS[3] pin VDDd VSSd enable_buf swmatrix_Tgate
xTgates[4] Q[4] BUS[4] pin VDDd VSSd enable_buf swmatrix_Tgate
xTgates[5] Q[5] BUS[5] pin VDDd VSSd enable_buf swmatrix_Tgate
xTgates[6] Q[6] BUS[6] pin VDDd VSSd enable_buf swmatrix_Tgate
xTgates[7] Q[7] BUS[7] pin VDDd VSSd enable_buf swmatrix_Tgate
xTgates[8] Q[8] BUS[8] pin VDDd VSSd enable_buf swmatrix_Tgate
xTgates[9] Q[9] BUS[9] pin VDDd VSSd enable_buf swmatrix_Tgate
xTgates[10] Q[10] BUS[10] pin VDDd VSSd enable_buf swmatrix_Tgate
xTgates[11] Q[11] BUS[11] pin VDDd VSSd enable_buf swmatrix_Tgate
xTgates[12] Q[12] BUS[12] pin VDDd VSSd enable_buf swmatrix_Tgate
xTgates[13] Q[13] BUS[13] pin VDDd VSSd enable_buf swmatrix_Tgate
xTgates[14] Q[14] BUS[14] pin VDDd VSSd enable_buf swmatrix_Tgate
xTgates[15] Q[15] BUS[15] pin VDDd VSSd enable_buf swmatrix_Tgate
xTgates[16] Q[16] BUS[16] pin VDDd VSSd enable_buf swmatrix_Tgate
xTgates[17] Q[17] BUS[17] pin VDDd VSSd enable_buf swmatrix_Tgate
xTgates[18] Q[18] BUS[18] pin VDDd VSSd enable_buf swmatrix_Tgate
xTgates[19] Q[19] BUS[19] pin VDDd VSSd enable_buf swmatrix_Tgate
xTgates[20] Q[20] BUS[20] pin VDDd VSSd enable_buf swmatrix_Tgate
xTgates[21] Q[21] BUS[21] pin VDDd VSSd enable_buf swmatrix_Tgate
xTgates[22] Q[22] BUS[22] pin VDDd VSSd enable_buf swmatrix_Tgate
xTgates[23] Q[23] BUS[23] pin VDDd VSSd enable_buf swmatrix_Tgate
xTgates[24] Q[24] BUS[24] pin VDDd VSSd enable_buf swmatrix_Tgate
xTgates[25] D_out BUS[25] pin VDDd VSSd enable_buf swmatrix_Tgate
x1 net1 net2 VDDd VDDd VSSd VSSd gf180mcu_fd_sc_mcu9t5v0__inv_8
x4 PHI_1 net1 VDDd VDDd VSSd VSSd gf180mcu_fd_sc_mcu9t5v0__inv_4
x5 net2 net3 VDDd VDDd VSSd VSSd gf180mcu_fd_sc_mcu9t5v0__inv_12
x7 net3 PHI_1_buf VDDd VDDd VSSd VSSd gf180mcu_fd_sc_mcu9t5v0__inv_20
x9 net4 net5 VDDd VDDd VSSd VSSd gf180mcu_fd_sc_mcu9t5v0__inv_8
x10 PHI_2 net4 VDDd VDDd VSSd VSSd gf180mcu_fd_sc_mcu9t5v0__inv_4
x11 net5 net6 VDDd VDDd VSSd VSSd gf180mcu_fd_sc_mcu9t5v0__inv_12
x12 net6 PHI_2_buf VDDd VDDd VSSd VSSd gf180mcu_fd_sc_mcu9t5v0__inv_20
x2 net7 net8 VDDd VDDd VSSd VSSd gf180mcu_fd_sc_mcu9t5v0__inv_8
x3 enable net7 VDDd VDDd VSSd VSSd gf180mcu_fd_sc_mcu9t5v0__inv_4
x6 net8 net9 VDDd VDDd VSSd VSSd gf180mcu_fd_sc_mcu9t5v0__inv_12
x8 net9 enable_buf VDDd VDDd VSSd VSSd gf180mcu_fd_sc_mcu9t5v0__inv_20
.ends

* expanding   symbol:  switch_matrix_gf180mcu_9t5v0/NO_ClkGen/NO_ClkGen.sym # of pins=5
** sym_path: /foss/designs/libs/switch_matrix_gf180mcu_9t5v0/NO_ClkGen/NO_ClkGen.sym
** sch_path: /foss/designs/libs/switch_matrix_gf180mcu_9t5v0/NO_ClkGen/NO_ClkGen.sch
.subckt NO_ClkGen PHI_2 CLK PHI_1 VDDd VSSd
*.PININFO CLK:I PHI_2:O PHI_1:O VDDd:B VSSd:B
x1 CLKB OUT_bot_d OUT_top VDDd VDDd VSSd VSSd gf180mcu_fd_sc_mcu9t5v0__nand2_1
x2 OUT_top_d CLKbuf OUT_bot VDDd VDDd VSSd VSSd gf180mcu_fd_sc_mcu9t5v0__nand2_1
x3 OUT_top PHI_2 VDDd VDDd VSSd VSSd gf180mcu_fd_sc_mcu9t5v0__inv_1
x4 PHI_2 in_d_2 VDDd VDDd VSSd VSSd gf180mcu_fd_sc_mcu9t5v0__inv_1
x6 OUT_bot PHI_1 VDDd VDDd VSSd VSSd gf180mcu_fd_sc_mcu9t5v0__inv_1
x9 CLKB CLKbuf VDDd VDDd VSSd VSSd gf180mcu_fd_sc_mcu9t5v0__inv_1
x10 CLK CLKB VDDd VDDd VSSd VSSd gf180mcu_fd_sc_mcu9t5v0__inv_1
* noconn VDDd
* noconn VSSd
xinv1[1] in_d_2 out_2[1] VDDd VDDd VSSd VSSd gf180mcu_fd_sc_mcu9t5v0__inv_1
xinv1[2] out_2[1] out_2[2] VDDd VDDd VSSd VSSd gf180mcu_fd_sc_mcu9t5v0__inv_1
xinv1[3] out_2[2] out_2[3] VDDd VDDd VSSd VSSd gf180mcu_fd_sc_mcu9t5v0__inv_1
xinv1[4] out_2[3] out_2[4] VDDd VDDd VSSd VSSd gf180mcu_fd_sc_mcu9t5v0__inv_1
xinv1[5] out_2[4] out_2[5] VDDd VDDd VSSd VSSd gf180mcu_fd_sc_mcu9t5v0__inv_1
xinv1[6] out_2[5] out_2[6] VDDd VDDd VSSd VSSd gf180mcu_fd_sc_mcu9t5v0__inv_1
xinv1[7] out_2[6] out_2[7] VDDd VDDd VSSd VSSd gf180mcu_fd_sc_mcu9t5v0__inv_1
xinv1[8] out_2[7] out_2[8] VDDd VDDd VSSd VSSd gf180mcu_fd_sc_mcu9t5v0__inv_1
xinv1[9] out_2[8] out_2[9] VDDd VDDd VSSd VSSd gf180mcu_fd_sc_mcu9t5v0__inv_1
xinv1[10] out_2[9] out_2[10] VDDd VDDd VSSd VSSd gf180mcu_fd_sc_mcu9t5v0__inv_1
xinv1[11] out_2[10] out_2[11] VDDd VDDd VSSd VSSd gf180mcu_fd_sc_mcu9t5v0__inv_1
xinv1[12] out_2[11] out_2[12] VDDd VDDd VSSd VSSd gf180mcu_fd_sc_mcu9t5v0__inv_1
xinv1[13] out_2[12] out_2[13] VDDd VDDd VSSd VSSd gf180mcu_fd_sc_mcu9t5v0__inv_1
xinv1[14] out_2[13] out_2[14] VDDd VDDd VSSd VSSd gf180mcu_fd_sc_mcu9t5v0__inv_1
xinv1[15] out_2[14] out_2[15] VDDd VDDd VSSd VSSd gf180mcu_fd_sc_mcu9t5v0__inv_1
xinv1[16] out_2[15] out_2[16] VDDd VDDd VSSd VSSd gf180mcu_fd_sc_mcu9t5v0__inv_1
xinv1[17] out_2[16] out_2[17] VDDd VDDd VSSd VSSd gf180mcu_fd_sc_mcu9t5v0__inv_1
xinv1[18] out_2[17] out_2[18] VDDd VDDd VSSd VSSd gf180mcu_fd_sc_mcu9t5v0__inv_1
xinv1[19] out_2[18] out_2[19] VDDd VDDd VSSd VSSd gf180mcu_fd_sc_mcu9t5v0__inv_1
xinv1[20] out_2[19] OUT_top_d VDDd VDDd VSSd VSSd gf180mcu_fd_sc_mcu9t5v0__inv_1
x5 PHI_1 in_d_1 VDDd VDDd VSSd VSSd gf180mcu_fd_sc_mcu9t5v0__inv_1
xinv2[1] in_d_1 out_1[1] VDDd VDDd VSSd VSSd gf180mcu_fd_sc_mcu9t5v0__inv_1
xinv2[2] out_1[1] out_1[2] VDDd VDDd VSSd VSSd gf180mcu_fd_sc_mcu9t5v0__inv_1
xinv2[3] out_1[2] out_1[3] VDDd VDDd VSSd VSSd gf180mcu_fd_sc_mcu9t5v0__inv_1
xinv2[4] out_1[3] out_1[4] VDDd VDDd VSSd VSSd gf180mcu_fd_sc_mcu9t5v0__inv_1
xinv2[5] out_1[4] out_1[5] VDDd VDDd VSSd VSSd gf180mcu_fd_sc_mcu9t5v0__inv_1
xinv2[6] out_1[5] out_1[6] VDDd VDDd VSSd VSSd gf180mcu_fd_sc_mcu9t5v0__inv_1
xinv2[7] out_1[6] out_1[7] VDDd VDDd VSSd VSSd gf180mcu_fd_sc_mcu9t5v0__inv_1
xinv2[8] out_1[7] out_1[8] VDDd VDDd VSSd VSSd gf180mcu_fd_sc_mcu9t5v0__inv_1
xinv2[9] out_1[8] out_1[9] VDDd VDDd VSSd VSSd gf180mcu_fd_sc_mcu9t5v0__inv_1
xinv2[10] out_1[9] out_1[10] VDDd VDDd VSSd VSSd gf180mcu_fd_sc_mcu9t5v0__inv_1
xinv2[11] out_1[10] out_1[11] VDDd VDDd VSSd VSSd gf180mcu_fd_sc_mcu9t5v0__inv_1
xinv2[12] out_1[11] out_1[12] VDDd VDDd VSSd VSSd gf180mcu_fd_sc_mcu9t5v0__inv_1
xinv2[13] out_1[12] out_1[13] VDDd VDDd VSSd VSSd gf180mcu_fd_sc_mcu9t5v0__inv_1
xinv2[14] out_1[13] out_1[14] VDDd VDDd VSSd VSSd gf180mcu_fd_sc_mcu9t5v0__inv_1
xinv2[15] out_1[14] out_1[15] VDDd VDDd VSSd VSSd gf180mcu_fd_sc_mcu9t5v0__inv_1
xinv2[16] out_1[15] out_1[16] VDDd VDDd VSSd VSSd gf180mcu_fd_sc_mcu9t5v0__inv_1
xinv2[17] out_1[16] out_1[17] VDDd VDDd VSSd VSSd gf180mcu_fd_sc_mcu9t5v0__inv_1
xinv2[18] out_1[17] out_1[18] VDDd VDDd VSSd VSSd gf180mcu_fd_sc_mcu9t5v0__inv_1
xinv2[19] out_1[18] out_1[19] VDDd VDDd VSSd VSSd gf180mcu_fd_sc_mcu9t5v0__inv_1
xinv2[20] out_1[19] OUT_bot_d VDDd VDDd VSSd VSSd gf180mcu_fd_sc_mcu9t5v0__inv_1
XMcapbot[1] VSSd out_1[1] VSSd VSSd nfet_06v0 L=1u W=25u nf=5 m=1
XMcapbot[2] VSSd out_1[2] VSSd VSSd nfet_06v0 L=1u W=25u nf=5 m=1
XMcapbot[3] VSSd out_1[3] VSSd VSSd nfet_06v0 L=1u W=25u nf=5 m=1
XMcapbot[4] VSSd out_1[4] VSSd VSSd nfet_06v0 L=1u W=25u nf=5 m=1
XMcapbot[5] VSSd out_1[5] VSSd VSSd nfet_06v0 L=1u W=25u nf=5 m=1
XMcapbot[6] VSSd out_1[6] VSSd VSSd nfet_06v0 L=1u W=25u nf=5 m=1
XMcapbot[7] VSSd out_1[7] VSSd VSSd nfet_06v0 L=1u W=25u nf=5 m=1
XMcapbot[8] VSSd out_1[8] VSSd VSSd nfet_06v0 L=1u W=25u nf=5 m=1
XMcapbot[9] VSSd out_1[9] VSSd VSSd nfet_06v0 L=1u W=25u nf=5 m=1
XMcapbot[10] VSSd out_1[10] VSSd VSSd nfet_06v0 L=1u W=25u nf=5 m=1
XMcapbot[11] VSSd out_1[11] VSSd VSSd nfet_06v0 L=1u W=25u nf=5 m=1
XMcapbot[12] VSSd out_1[12] VSSd VSSd nfet_06v0 L=1u W=25u nf=5 m=1
XMcapbot[13] VSSd out_1[13] VSSd VSSd nfet_06v0 L=1u W=25u nf=5 m=1
XMcapbot[14] VSSd out_1[14] VSSd VSSd nfet_06v0 L=1u W=25u nf=5 m=1
XMcapbot[15] VSSd out_1[15] VSSd VSSd nfet_06v0 L=1u W=25u nf=5 m=1
XMcapbot[16] VSSd out_1[16] VSSd VSSd nfet_06v0 L=1u W=25u nf=5 m=1
XMcapbot[17] VSSd out_1[17] VSSd VSSd nfet_06v0 L=1u W=25u nf=5 m=1
XMcapbot[18] VSSd out_1[18] VSSd VSSd nfet_06v0 L=1u W=25u nf=5 m=1
XMcapbot[19] VSSd out_1[19] VSSd VSSd nfet_06v0 L=1u W=25u nf=5 m=1
XMcapbot[20] VSSd OUT_bot_d VSSd VSSd nfet_06v0 L=1u W=25u nf=5 m=1
XMcaptop[1] VSSd out_2[1] VSSd VSSd nfet_06v0 L=1u W=25u nf=5 m=1
XMcaptop[2] VSSd out_2[2] VSSd VSSd nfet_06v0 L=1u W=25u nf=5 m=1
XMcaptop[3] VSSd out_2[3] VSSd VSSd nfet_06v0 L=1u W=25u nf=5 m=1
XMcaptop[4] VSSd out_2[4] VSSd VSSd nfet_06v0 L=1u W=25u nf=5 m=1
XMcaptop[5] VSSd out_2[5] VSSd VSSd nfet_06v0 L=1u W=25u nf=5 m=1
XMcaptop[6] VSSd out_2[6] VSSd VSSd nfet_06v0 L=1u W=25u nf=5 m=1
XMcaptop[7] VSSd out_2[7] VSSd VSSd nfet_06v0 L=1u W=25u nf=5 m=1
XMcaptop[8] VSSd out_2[8] VSSd VSSd nfet_06v0 L=1u W=25u nf=5 m=1
XMcaptop[9] VSSd out_2[9] VSSd VSSd nfet_06v0 L=1u W=25u nf=5 m=1
XMcaptop[10] VSSd out_2[10] VSSd VSSd nfet_06v0 L=1u W=25u nf=5 m=1
XMcaptop[11] VSSd out_2[11] VSSd VSSd nfet_06v0 L=1u W=25u nf=5 m=1
XMcaptop[12] VSSd out_2[12] VSSd VSSd nfet_06v0 L=1u W=25u nf=5 m=1
XMcaptop[13] VSSd out_2[13] VSSd VSSd nfet_06v0 L=1u W=25u nf=5 m=1
XMcaptop[14] VSSd out_2[14] VSSd VSSd nfet_06v0 L=1u W=25u nf=5 m=1
XMcaptop[15] VSSd out_2[15] VSSd VSSd nfet_06v0 L=1u W=25u nf=5 m=1
XMcaptop[16] VSSd out_2[16] VSSd VSSd nfet_06v0 L=1u W=25u nf=5 m=1
XMcaptop[17] VSSd out_2[17] VSSd VSSd nfet_06v0 L=1u W=25u nf=5 m=1
XMcaptop[18] VSSd out_2[18] VSSd VSSd nfet_06v0 L=1u W=25u nf=5 m=1
XMcaptop[19] VSSd out_2[19] VSSd VSSd nfet_06v0 L=1u W=25u nf=5 m=1
XMcaptop[20] VSSd OUT_top_d VSSd VSSd nfet_06v0 L=1u W=25u nf=5 m=1
XMcapbotp[1] VDDd out_1[1] VDDd VDDd pfet_06v0 L=1u W=25u nf=5 m=1
XMcapbotp[2] VDDd out_1[2] VDDd VDDd pfet_06v0 L=1u W=25u nf=5 m=1
XMcapbotp[3] VDDd out_1[3] VDDd VDDd pfet_06v0 L=1u W=25u nf=5 m=1
XMcapbotp[4] VDDd out_1[4] VDDd VDDd pfet_06v0 L=1u W=25u nf=5 m=1
XMcapbotp[5] VDDd out_1[5] VDDd VDDd pfet_06v0 L=1u W=25u nf=5 m=1
XMcapbotp[6] VDDd out_1[6] VDDd VDDd pfet_06v0 L=1u W=25u nf=5 m=1
XMcapbotp[7] VDDd out_1[7] VDDd VDDd pfet_06v0 L=1u W=25u nf=5 m=1
XMcapbotp[8] VDDd out_1[8] VDDd VDDd pfet_06v0 L=1u W=25u nf=5 m=1
XMcapbotp[9] VDDd out_1[9] VDDd VDDd pfet_06v0 L=1u W=25u nf=5 m=1
XMcapbotp[10] VDDd out_1[10] VDDd VDDd pfet_06v0 L=1u W=25u nf=5 m=1
XMcapbotp[11] VDDd out_1[11] VDDd VDDd pfet_06v0 L=1u W=25u nf=5 m=1
XMcapbotp[12] VDDd out_1[12] VDDd VDDd pfet_06v0 L=1u W=25u nf=5 m=1
XMcapbotp[13] VDDd out_1[13] VDDd VDDd pfet_06v0 L=1u W=25u nf=5 m=1
XMcapbotp[14] VDDd out_1[14] VDDd VDDd pfet_06v0 L=1u W=25u nf=5 m=1
XMcapbotp[15] VDDd out_1[15] VDDd VDDd pfet_06v0 L=1u W=25u nf=5 m=1
XMcapbotp[16] VDDd out_1[16] VDDd VDDd pfet_06v0 L=1u W=25u nf=5 m=1
XMcapbotp[17] VDDd out_1[17] VDDd VDDd pfet_06v0 L=1u W=25u nf=5 m=1
XMcapbotp[18] VDDd out_1[18] VDDd VDDd pfet_06v0 L=1u W=25u nf=5 m=1
XMcapbotp[19] VDDd out_1[19] VDDd VDDd pfet_06v0 L=1u W=25u nf=5 m=1
XMcapbotp[20] VDDd OUT_bot_d VDDd VDDd pfet_06v0 L=1u W=25u nf=5 m=1
XMcaptopp[1] VDDd out_2[1] VDDd VDDd pfet_06v0 L=1u W=25u nf=5 m=1
XMcaptopp[2] VDDd out_2[2] VDDd VDDd pfet_06v0 L=1u W=25u nf=5 m=1
XMcaptopp[3] VDDd out_2[3] VDDd VDDd pfet_06v0 L=1u W=25u nf=5 m=1
XMcaptopp[4] VDDd out_2[4] VDDd VDDd pfet_06v0 L=1u W=25u nf=5 m=1
XMcaptopp[5] VDDd out_2[5] VDDd VDDd pfet_06v0 L=1u W=25u nf=5 m=1
XMcaptopp[6] VDDd out_2[6] VDDd VDDd pfet_06v0 L=1u W=25u nf=5 m=1
XMcaptopp[7] VDDd out_2[7] VDDd VDDd pfet_06v0 L=1u W=25u nf=5 m=1
XMcaptopp[8] VDDd out_2[8] VDDd VDDd pfet_06v0 L=1u W=25u nf=5 m=1
XMcaptopp[9] VDDd out_2[9] VDDd VDDd pfet_06v0 L=1u W=25u nf=5 m=1
XMcaptopp[10] VDDd out_2[10] VDDd VDDd pfet_06v0 L=1u W=25u nf=5 m=1
XMcaptopp[11] VDDd out_2[11] VDDd VDDd pfet_06v0 L=1u W=25u nf=5 m=1
XMcaptopp[12] VDDd out_2[12] VDDd VDDd pfet_06v0 L=1u W=25u nf=5 m=1
XMcaptopp[13] VDDd out_2[13] VDDd VDDd pfet_06v0 L=1u W=25u nf=5 m=1
XMcaptopp[14] VDDd out_2[14] VDDd VDDd pfet_06v0 L=1u W=25u nf=5 m=1
XMcaptopp[15] VDDd out_2[15] VDDd VDDd pfet_06v0 L=1u W=25u nf=5 m=1
XMcaptopp[16] VDDd out_2[16] VDDd VDDd pfet_06v0 L=1u W=25u nf=5 m=1
XMcaptopp[17] VDDd out_2[17] VDDd VDDd pfet_06v0 L=1u W=25u nf=5 m=1
XMcaptopp[18] VDDd out_2[18] VDDd VDDd pfet_06v0 L=1u W=25u nf=5 m=1
XMcaptopp[19] VDDd out_2[19] VDDd VDDd pfet_06v0 L=1u W=25u nf=5 m=1
XMcaptopp[20] VDDd OUT_top_d VDDd VDDd pfet_06v0 L=1u W=25u nf=5 m=1
.ends

* expanding   symbol:  switch_matrix_gf180mcu_9t5v0/Schmitt/Schmitt.sym # of pins=4
** sym_path: /foss/designs/libs/switch_matrix_gf180mcu_9t5v0/Schmitt/Schmitt.sym
** sch_path: /foss/designs/libs/switch_matrix_gf180mcu_9t5v0/Schmitt/Schmitt.sch
.subckt Schmitt VDD Vin Vo VSS
*.PININFO VDD:I VSS:I Vin:I Vo:O
XM9 schmitt Vin bot VSS nfet_06v0 L=0.70u W=2u nf=2 m=1
XM10 schmitt Vin top VDD pfet_06v0 L=0.55u W=6u nf=2 m=1
XM11 VDD schmitt bot VSS nfet_06v0 L=0.70u W=2u nf=2 m=1
XM12 top Vin VDD VDD pfet_06v0 L=0.55u W=6u nf=2 m=1
XM13 Vo schmitt VSS VSS nfet_06v0 L=0.70u W=2u nf=2 m=1
XM14 Vo schmitt VDD VDD pfet_06v0 L=0.55u W=6u nf=2 m=1
XM15 VSS schmitt top VDD pfet_06v0 L=0.55u W=6u nf=2 m=1
XM1 bot Vin VSS VSS nfet_06v0 L=0.70u W=2u nf=2 m=1
.ends

* expanding   symbol:  switch_matrix_gf180mcu_9t5v0/ShiftReg_row_25/ShiftReg_row_25.sym # of pins=6
** sym_path: /foss/designs/libs/switch_matrix_gf180mcu_9t5v0/ShiftReg_row_25/ShiftReg_row_25.sym
** sch_path: /foss/designs/libs/switch_matrix_gf180mcu_9t5v0/ShiftReg_row_25/ShiftReg_row_25.sch
.subckt ShiftReg_row_25 Q[1] Q[2] Q[3] Q[4] Q[5] Q[6] Q[7] Q[8] Q[9] Q[10] Q[11] Q[12] Q[13] Q[14] Q[15] Q[16] Q[17] Q[18] Q[19]
+ Q[20] Q[21] Q[22] Q[23] Q[24] Q[25] D_in PHI_1 PHI_2 VDDd VSSd
*.PININFO PHI_1:I PHI_2:I D_in:I Q[1:25]:O VDDd:B VSSd:B
xFF[1] D_in Q[1] PHI_1 PHI_2 VDDd VSSd DFF_2phase_1
xFF[2] Q[1] Q[2] PHI_1 PHI_2 VDDd VSSd DFF_2phase_1
xFF[3] Q[2] Q[3] PHI_1 PHI_2 VDDd VSSd DFF_2phase_1
xFF[4] Q[3] Q[4] PHI_1 PHI_2 VDDd VSSd DFF_2phase_1
xFF[5] Q[4] Q[5] PHI_1 PHI_2 VDDd VSSd DFF_2phase_1
xFF[6] Q[5] Q[6] PHI_1 PHI_2 VDDd VSSd DFF_2phase_1
xFF[7] Q[6] Q[7] PHI_1 PHI_2 VDDd VSSd DFF_2phase_1
xFF[8] Q[7] Q[8] PHI_1 PHI_2 VDDd VSSd DFF_2phase_1
xFF[9] Q[8] Q[9] PHI_1 PHI_2 VDDd VSSd DFF_2phase_1
xFF[10] Q[9] Q[10] PHI_1 PHI_2 VDDd VSSd DFF_2phase_1
xFF[11] Q[10] Q[11] PHI_1 PHI_2 VDDd VSSd DFF_2phase_1
xFF[12] Q[11] Q[12] PHI_1 PHI_2 VDDd VSSd DFF_2phase_1
xFF[13] Q[12] Q[13] PHI_1 PHI_2 VDDd VSSd DFF_2phase_1
xFF[14] Q[13] Q[14] PHI_1 PHI_2 VDDd VSSd DFF_2phase_1
xFF[15] Q[14] Q[15] PHI_1 PHI_2 VDDd VSSd DFF_2phase_1
xFF[16] Q[15] Q[16] PHI_1 PHI_2 VDDd VSSd DFF_2phase_1
xFF[17] Q[16] Q[17] PHI_1 PHI_2 VDDd VSSd DFF_2phase_1
xFF[18] Q[17] Q[18] PHI_1 PHI_2 VDDd VSSd DFF_2phase_1
xFF[19] Q[18] Q[19] PHI_1 PHI_2 VDDd VSSd DFF_2phase_1
xFF[20] Q[19] Q[20] PHI_1 PHI_2 VDDd VSSd DFF_2phase_1
xFF[21] Q[20] Q[21] PHI_1 PHI_2 VDDd VSSd DFF_2phase_1
xFF[22] Q[21] Q[22] PHI_1 PHI_2 VDDd VSSd DFF_2phase_1
xFF[23] Q[22] Q[23] PHI_1 PHI_2 VDDd VSSd DFF_2phase_1
xFF[24] Q[23] Q[24] PHI_1 PHI_2 VDDd VSSd DFF_2phase_1
xFF[25] Q[24] Q[25] PHI_1 PHI_2 VDDd VSSd DFF_2phase_1
.ends

* expanding   symbol:  switch_matrix_gf180mcu_9t5v0/swmatrix_Tgate/swmatrix_Tgate.sym # of pins=6
** sym_path: /foss/designs/libs/switch_matrix_gf180mcu_9t5v0/swmatrix_Tgate/swmatrix_Tgate.sym
** sch_path: /foss/designs/libs/switch_matrix_gf180mcu_9t5v0/swmatrix_Tgate/swmatrix_Tgate.sch
.subckt swmatrix_Tgate control T2 T1 VDDd VSSd enable
*.PININFO T1:B T2:B VDDd:B VSSd:B control:I enable:I
XM1 T1 gated_control T2 VSSd nfet_03v3 L=0.28u W=48u nf=6 m=1
XM2 T1 gated_controlb T2 VDDd pfet_03v3 L=0.28u W=144u nf=18 m=1
**** begin user architecture code

.param mn_w=48u
.param mp_w=144u

**** end user architecture code
x1 gated_control gated_controlb VDDd VDDd VSSd VSSd gf180mcu_fd_sc_mcu9t5v0__inv_1
x2 control enable net1 VDDd VDDd VSSd VSSd gf180mcu_fd_sc_mcu9t5v0__nand2_1
x3 net1 gated_control VDDd VDDd VSSd VSSd gf180mcu_fd_sc_mcu9t5v0__inv_1
.ends

* expanding   symbol:  switch_matrix_gf180mcu_9t5v0/DFF_2phase_1/DFF_2phase_1.sym # of pins=6
** sym_path: /foss/designs/libs/switch_matrix_gf180mcu_9t5v0/DFF_2phase_1/DFF_2phase_1.sym
** sch_path: /foss/designs/libs/switch_matrix_gf180mcu_9t5v0/DFF_2phase_1/DFF_2phase_1.sch
.subckt DFF_2phase_1 D Q PHI_1 PHI_2 VDDd VSSd
*.PININFO D:I PHI_1:I PHI_2:I Q:O VDDd:B VSSd:B
xmain D PHI_1 out_m VDDd VDDd VSSd VSSd gf180mcu_fd_sc_mcu9t5v0__latq_1
xsecondary out_m PHI_2 Q VDDd VDDd VSSd VSSd gf180mcu_fd_sc_mcu9t5v0__latq_1
* noconn VSSd
* noconn VDDd
.ends
