* NGSPICE file created from swmatrix_25_by_130_no_probe.ext - technology: gf180mcuD

.subckt gf180mcu_fd_sc_mcu9t5v0__inv_20 I VDD VSS ZN VNW VPW
X0 ZN I VDD VNW pfet_05v0 ad=0.5673p pd=2.45u as=0.5673p ps=2.45u w=1.83u l=0.5u
X1 VDD I ZN VNW pfet_05v0 ad=0.5673p pd=2.45u as=0.5673p ps=2.45u w=1.83u l=0.5u
X2 VSS I ZN VPW nfet_05v0 ad=0.3432p pd=1.84u as=0.3432p ps=1.84u w=1.32u l=0.6u
X3 ZN I VDD VNW pfet_05v0 ad=0.5673p pd=2.45u as=0.5673p ps=2.45u w=1.83u l=0.5u
X4 VSS I ZN VPW nfet_05v0 ad=0.3432p pd=1.84u as=0.3432p ps=1.84u w=1.32u l=0.6u
X5 VDD I ZN VNW pfet_05v0 ad=0.5673p pd=2.45u as=0.5673p ps=2.45u w=1.83u l=0.5u
X6 ZN I VDD VNW pfet_05v0 ad=0.5673p pd=2.45u as=0.5673p ps=2.45u w=1.83u l=0.5u
X7 VSS I ZN VPW nfet_05v0 ad=0.3432p pd=1.84u as=0.3432p ps=1.84u w=1.32u l=0.6u
X8 ZN I VSS VPW nfet_05v0 ad=0.3432p pd=1.84u as=0.3432p ps=1.84u w=1.32u l=0.6u
X9 ZN I VSS VPW nfet_05v0 ad=0.3432p pd=1.84u as=0.3432p ps=1.84u w=1.32u l=0.6u
X10 VDD I ZN VNW pfet_05v0 ad=0.5673p pd=2.45u as=0.5673p ps=2.45u w=1.83u l=0.5u
X11 VDD I ZN VNW pfet_05v0 ad=0.8052p pd=4.54u as=0.5673p ps=2.45u w=1.83u l=0.5u
X12 ZN I VSS VPW nfet_05v0 ad=0.3432p pd=1.84u as=0.3432p ps=1.84u w=1.32u l=0.6u
X13 ZN I VDD VNW pfet_05v0 ad=0.5673p pd=2.45u as=0.5673p ps=2.45u w=1.83u l=0.5u
X14 ZN I VSS VPW nfet_05v0 ad=0.3432p pd=1.84u as=0.3432p ps=1.84u w=1.32u l=0.6u
X15 VSS I ZN VPW nfet_05v0 ad=0.3432p pd=1.84u as=0.3432p ps=1.84u w=1.32u l=0.6u
X16 VSS I ZN VPW nfet_05v0 ad=0.3432p pd=1.84u as=0.3432p ps=1.84u w=1.32u l=0.6u
X17 VDD I ZN VNW pfet_05v0 ad=0.5673p pd=2.45u as=0.5673p ps=2.45u w=1.83u l=0.5u
X18 VDD I ZN VNW pfet_05v0 ad=0.5673p pd=2.45u as=0.5673p ps=2.45u w=1.83u l=0.5u
X19 VDD I ZN VNW pfet_05v0 ad=0.5673p pd=2.45u as=0.5673p ps=2.45u w=1.83u l=0.5u
X20 ZN I VSS VPW nfet_05v0 ad=0.3432p pd=1.84u as=0.5808p ps=3.52u w=1.32u l=0.6u
X21 ZN I VDD VNW pfet_05v0 ad=0.5673p pd=2.45u as=0.5673p ps=2.45u w=1.83u l=0.5u
X22 ZN I VSS VPW nfet_05v0 ad=0.3432p pd=1.84u as=0.3432p ps=1.84u w=1.32u l=0.6u
X23 VSS I ZN VPW nfet_05v0 ad=0.3432p pd=1.84u as=0.3432p ps=1.84u w=1.32u l=0.6u
X24 ZN I VDD VNW pfet_05v0 ad=0.5673p pd=2.45u as=0.5673p ps=2.45u w=1.83u l=0.5u
X25 VSS I ZN VPW nfet_05v0 ad=0.3432p pd=1.84u as=0.3432p ps=1.84u w=1.32u l=0.6u
X26 VDD I ZN VNW pfet_05v0 ad=0.5673p pd=2.45u as=0.5673p ps=2.45u w=1.83u l=0.5u
X27 ZN I VSS VPW nfet_05v0 ad=0.3432p pd=1.84u as=0.3432p ps=1.84u w=1.32u l=0.6u
X28 ZN I VSS VPW nfet_05v0 ad=0.3432p pd=1.84u as=0.3432p ps=1.84u w=1.32u l=0.6u
X29 VSS I ZN VPW nfet_05v0 ad=0.5808p pd=3.52u as=0.3432p ps=1.84u w=1.32u l=0.6u
X30 VDD I ZN VNW pfet_05v0 ad=0.5673p pd=2.45u as=0.5673p ps=2.45u w=1.83u l=0.5u
X31 ZN I VSS VPW nfet_05v0 ad=0.3432p pd=1.84u as=0.3432p ps=1.84u w=1.32u l=0.6u
X32 ZN I VDD VNW pfet_05v0 ad=0.5673p pd=2.45u as=0.5673p ps=2.45u w=1.83u l=0.5u
X33 ZN I VDD VNW pfet_05v0 ad=0.5673p pd=2.45u as=0.5673p ps=2.45u w=1.83u l=0.5u
X34 ZN I VSS VPW nfet_05v0 ad=0.3432p pd=1.84u as=0.3432p ps=1.84u w=1.32u l=0.6u
X35 ZN I VDD VNW pfet_05v0 ad=0.5673p pd=2.45u as=0.8052p ps=4.54u w=1.83u l=0.5u
X36 VDD I ZN VNW pfet_05v0 ad=0.5673p pd=2.45u as=0.5673p ps=2.45u w=1.83u l=0.5u
X37 VSS I ZN VPW nfet_05v0 ad=0.3432p pd=1.84u as=0.3432p ps=1.84u w=1.32u l=0.6u
X38 ZN I VDD VNW pfet_05v0 ad=0.5673p pd=2.45u as=0.5673p ps=2.45u w=1.83u l=0.5u
X39 VSS I ZN VPW nfet_05v0 ad=0.3432p pd=1.84u as=0.3432p ps=1.84u w=1.32u l=0.6u
.ends

.subckt gf180mcu_fd_sc_mcu9t5v0__inv_1$1 I VDD VSS ZN VNW VPW
X0 ZN I VDD VNW pfet_05v0 ad=0.8052p pd=4.54u as=0.8052p ps=4.54u w=1.83u l=0.5u
X1 ZN I VSS VPW nfet_05v0 ad=0.5808p pd=3.52u as=0.5808p ps=3.52u w=1.32u l=0.6u
.ends

.subckt nfet$1 a_350_1660# a_734_0# a_254_0# a_894_0# a_510_1660# a_670_1660# a_414_0#
+ a_n84_0# a_94_0# a_574_0# a_830_1660# a_30_1660# a_190_1660# VSUBS
X0 a_734_0# a_670_1660# a_574_0# VSUBS nfet_03v3 ad=2.08p pd=8.52u as=2.08p ps=8.52u w=8u l=0.28u
X1 a_254_0# a_190_1660# a_94_0# VSUBS nfet_03v3 ad=2.08p pd=8.52u as=2.08p ps=8.52u w=8u l=0.28u
X2 a_574_0# a_510_1660# a_414_0# VSUBS nfet_03v3 ad=2.08p pd=8.52u as=2.08p ps=8.52u w=8u l=0.28u
X3 a_894_0# a_830_1660# a_734_0# VSUBS nfet_03v3 ad=4.88p pd=17.22u as=2.08p ps=8.52u w=8u l=0.28u
X4 a_94_0# a_30_1660# a_n84_0# VSUBS nfet_03v3 ad=2.08p pd=8.52u as=4.88p ps=17.22u w=8u l=0.28u
X5 a_414_0# a_350_1660# a_254_0# VSUBS nfet_03v3 ad=2.08p pd=8.52u as=2.08p ps=8.52u w=8u l=0.28u
.ends

.subckt gf180mcu_fd_sc_mcu9t5v0__nand2_1$1 A1 A2 VDD VSS ZN VNW VPW
X0 ZN A2 VDD VNW pfet_05v0 ad=0.4277p pd=2.165u as=0.7238p ps=4.17u w=1.645u l=0.5u
X1 VDD A1 ZN VNW pfet_05v0 ad=0.7238p pd=4.17u as=0.4277p ps=2.165u w=1.645u l=0.5u
X2 ZN A1 a_245_69# VPW nfet_05v0 ad=0.5808p pd=3.52u as=0.2112p ps=1.64u w=1.32u l=0.6u
X3 a_245_69# A2 VSS VPW nfet_05v0 ad=0.2112p pd=1.64u as=0.5808p ps=3.52u w=1.32u l=0.6u
.ends

.subckt pfet$1 a_1534_0# a_2174_0# a_1054_0# a_734_0# a_828_n136# a_28_n136# a_2588_n136#
+ a_1694_0# a_254_0# a_1628_n136# a_894_0# a_188_n136# a_988_n136# a_2814_0# a_2748_n136#
+ a_1788_n136# w_n180_n88# a_2334_0# a_348_n136# a_1214_0# a_1148_n136# a_1854_0#
+ a_414_0# a_2108_n136# a_2494_0# a_n92_0# a_1948_n136# a_1374_0# a_94_0# a_574_0#
+ a_508_n136# a_2268_n136# a_1308_n136# a_2014_0# a_668_n136# a_2428_n136# a_1468_n136#
+ a_2654_0#
X0 a_1214_0# a_1148_n136# a_1054_0# w_n180_n88# pfet_03v3 ad=2.08p pd=8.52u as=2.08p ps=8.52u w=8u l=0.28u
X1 a_2654_0# a_2588_n136# a_2494_0# w_n180_n88# pfet_03v3 ad=2.08p pd=8.52u as=2.08p ps=8.52u w=8u l=0.28u
X2 a_734_0# a_668_n136# a_574_0# w_n180_n88# pfet_03v3 ad=2.08p pd=8.52u as=2.08p ps=8.52u w=8u l=0.28u
X3 a_2494_0# a_2428_n136# a_2334_0# w_n180_n88# pfet_03v3 ad=2.08p pd=8.52u as=2.08p ps=8.52u w=8u l=0.28u
X4 a_254_0# a_188_n136# a_94_0# w_n180_n88# pfet_03v3 ad=2.08p pd=8.52u as=2.08p ps=8.52u w=8u l=0.28u
X5 a_574_0# a_508_n136# a_414_0# w_n180_n88# pfet_03v3 ad=2.08p pd=8.52u as=2.08p ps=8.52u w=8u l=0.28u
X6 a_2014_0# a_1948_n136# a_1854_0# w_n180_n88# pfet_03v3 ad=2.08p pd=8.52u as=2.08p ps=8.52u w=8u l=0.28u
X7 a_1534_0# a_1468_n136# a_1374_0# w_n180_n88# pfet_03v3 ad=2.08p pd=8.52u as=2.08p ps=8.52u w=8u l=0.28u
X8 a_1374_0# a_1308_n136# a_1214_0# w_n180_n88# pfet_03v3 ad=2.08p pd=8.52u as=2.08p ps=8.52u w=8u l=0.28u
X9 a_1054_0# a_988_n136# a_894_0# w_n180_n88# pfet_03v3 ad=2.08p pd=8.52u as=2.08p ps=8.52u w=8u l=0.28u
X10 a_2814_0# a_2748_n136# a_2654_0# w_n180_n88# pfet_03v3 ad=5.2p pd=17.3u as=2.08p ps=8.52u w=8u l=0.28u
X11 a_894_0# a_828_n136# a_734_0# w_n180_n88# pfet_03v3 ad=2.08p pd=8.52u as=2.08p ps=8.52u w=8u l=0.28u
X12 a_2334_0# a_2268_n136# a_2174_0# w_n180_n88# pfet_03v3 ad=2.08p pd=8.52u as=2.08p ps=8.52u w=8u l=0.28u
X13 a_94_0# a_28_n136# a_n92_0# w_n180_n88# pfet_03v3 ad=2.08p pd=8.52u as=5.2p ps=17.3u w=8u l=0.28u
X14 a_2174_0# a_2108_n136# a_2014_0# w_n180_n88# pfet_03v3 ad=2.08p pd=8.52u as=2.08p ps=8.52u w=8u l=0.28u
X15 a_414_0# a_348_n136# a_254_0# w_n180_n88# pfet_03v3 ad=2.08p pd=8.52u as=2.08p ps=8.52u w=8u l=0.28u
X16 a_1854_0# a_1788_n136# a_1694_0# w_n180_n88# pfet_03v3 ad=2.08p pd=8.52u as=2.08p ps=8.52u w=8u l=0.28u
X17 a_1694_0# a_1628_n136# a_1534_0# w_n180_n88# pfet_03v3 ad=2.08p pd=8.52u as=2.08p ps=8.52u w=8u l=0.28u
.ends

.subckt swmatrix_Tgate VDDd VSSd enable T1 T2 control
Xgf180mcu_fd_sc_mcu9t5v0__inv_1$1_0 gf180mcu_fd_sc_mcu9t5v0__inv_1$1_0/I VDDd VSSd
+ gf180mcu_fd_sc_mcu9t5v0__inv_1$1_0/ZN VDDd VSSd gf180mcu_fd_sc_mcu9t5v0__inv_1$1
Xgf180mcu_fd_sc_mcu9t5v0__inv_1$1_1 gf180mcu_fd_sc_mcu9t5v0__inv_1$1_1/I VDDd VSSd
+ gf180mcu_fd_sc_mcu9t5v0__inv_1$1_0/I VDDd VSSd gf180mcu_fd_sc_mcu9t5v0__inv_1$1
Xnfet$1_0 gf180mcu_fd_sc_mcu9t5v0__inv_1$1_0/I T2 T1 T1 gf180mcu_fd_sc_mcu9t5v0__inv_1$1_0/I
+ gf180mcu_fd_sc_mcu9t5v0__inv_1$1_0/I T2 T1 T2 T1 gf180mcu_fd_sc_mcu9t5v0__inv_1$1_0/I
+ gf180mcu_fd_sc_mcu9t5v0__inv_1$1_0/I gf180mcu_fd_sc_mcu9t5v0__inv_1$1_0/I VSSd nfet$1
Xgf180mcu_fd_sc_mcu9t5v0__nand2_1$1_0 control enable VDDd VSSd gf180mcu_fd_sc_mcu9t5v0__inv_1$1_1/I
+ VDDd VSSd gf180mcu_fd_sc_mcu9t5v0__nand2_1$1
Xpfet$1_0 T1 T1 T2 T2 gf180mcu_fd_sc_mcu9t5v0__inv_1$1_0/ZN gf180mcu_fd_sc_mcu9t5v0__inv_1$1_0/ZN
+ gf180mcu_fd_sc_mcu9t5v0__inv_1$1_0/ZN T2 T1 gf180mcu_fd_sc_mcu9t5v0__inv_1$1_0/ZN
+ T1 gf180mcu_fd_sc_mcu9t5v0__inv_1$1_0/ZN gf180mcu_fd_sc_mcu9t5v0__inv_1$1_0/ZN T1
+ gf180mcu_fd_sc_mcu9t5v0__inv_1$1_0/ZN gf180mcu_fd_sc_mcu9t5v0__inv_1$1_0/ZN VDDd
+ T2 gf180mcu_fd_sc_mcu9t5v0__inv_1$1_0/ZN T1 gf180mcu_fd_sc_mcu9t5v0__inv_1$1_0/ZN
+ T1 T2 gf180mcu_fd_sc_mcu9t5v0__inv_1$1_0/ZN T1 T1 gf180mcu_fd_sc_mcu9t5v0__inv_1$1_0/ZN
+ T2 T2 T1 gf180mcu_fd_sc_mcu9t5v0__inv_1$1_0/ZN gf180mcu_fd_sc_mcu9t5v0__inv_1$1_0/ZN
+ gf180mcu_fd_sc_mcu9t5v0__inv_1$1_0/ZN T2 gf180mcu_fd_sc_mcu9t5v0__inv_1$1_0/ZN gf180mcu_fd_sc_mcu9t5v0__inv_1$1_0/ZN
+ gf180mcu_fd_sc_mcu9t5v0__inv_1$1_0/ZN T2 pfet$1
.ends

.subckt gf180mcu_fd_sc_mcu9t5v0__inv_8 I VDD VSS ZN VNW VPW
X0 ZN I VDD VNW pfet_05v0 ad=0.5673p pd=2.45u as=0.5673p ps=2.45u w=1.83u l=0.5u
X1 VSS I ZN VPW nfet_05v0 ad=0.3432p pd=1.84u as=0.3432p ps=1.84u w=1.32u l=0.6u
X2 VDD I ZN VNW pfet_05v0 ad=0.5673p pd=2.45u as=0.5673p ps=2.45u w=1.83u l=0.5u
X3 VSS I ZN VPW nfet_05v0 ad=0.3432p pd=1.84u as=0.3432p ps=1.84u w=1.32u l=0.6u
X4 ZN I VSS VPW nfet_05v0 ad=0.3432p pd=1.84u as=0.3432p ps=1.84u w=1.32u l=0.6u
X5 VDD I ZN VNW pfet_05v0 ad=0.8052p pd=4.54u as=0.5673p ps=2.45u w=1.83u l=0.5u
X6 ZN I VSS VPW nfet_05v0 ad=0.3432p pd=1.84u as=0.3432p ps=1.84u w=1.32u l=0.6u
X7 VDD I ZN VNW pfet_05v0 ad=0.5673p pd=2.45u as=0.5673p ps=2.45u w=1.83u l=0.5u
X8 ZN I VSS VPW nfet_05v0 ad=0.3432p pd=1.84u as=0.5808p ps=3.52u w=1.32u l=0.6u
X9 ZN I VDD VNW pfet_05v0 ad=0.5673p pd=2.45u as=0.5673p ps=2.45u w=1.83u l=0.5u
X10 VDD I ZN VNW pfet_05v0 ad=0.5673p pd=2.45u as=0.5673p ps=2.45u w=1.83u l=0.5u
X11 ZN I VSS VPW nfet_05v0 ad=0.3432p pd=1.84u as=0.3432p ps=1.84u w=1.32u l=0.6u
X12 ZN I VDD VNW pfet_05v0 ad=0.5673p pd=2.45u as=0.5673p ps=2.45u w=1.83u l=0.5u
X13 ZN I VDD VNW pfet_05v0 ad=0.5673p pd=2.45u as=0.8052p ps=4.54u w=1.83u l=0.5u
X14 VSS I ZN VPW nfet_05v0 ad=0.5808p pd=3.52u as=0.3432p ps=1.84u w=1.32u l=0.6u
X15 VSS I ZN VPW nfet_05v0 ad=0.3432p pd=1.84u as=0.3432p ps=1.84u w=1.32u l=0.6u
.ends

.subckt gf180mcu_fd_sc_mcu9t5v0__latq_1$2 D E Q VDD VSS VNW VPW
X0 VSS a_1020_652# Q VPW nfet_05v0 ad=0.5808p pd=3.52u as=0.5808p ps=3.52u w=1.32u l=0.6u
X1 a_504_110# a_36_92# VDD VNW pfet_05v0 ad=0.44p pd=2.88u as=0.476p ps=2.18u w=1u l=0.5u
X2 VDD a_1020_652# Q VNW pfet_05v0 ad=0.8052p pd=4.54u as=0.8052p ps=4.54u w=1.83u l=0.5u
X3 a_1264_107# a_36_92# a_1020_652# VPW nfet_05v0 ad=0.263p pd=1.49u as=0.182p ps=1.22u w=0.7u l=0.6u
X4 VSS E a_36_92# VPW nfet_05v0 ad=0.263p pd=1.49u as=0.3476p ps=2.46u w=0.79u l=0.6u
X5 VSS a_1364_532# a_1264_107# VPW nfet_05v0 ad=0.2054p pd=1.31u as=0.263p ps=1.49u w=0.79u l=0.6u
X6 VDD E a_36_92# VNW pfet_05v0 ad=0.476p pd=2.18u as=0.6072p ps=3.64u w=1.38u l=0.5u
X7 VDD a_1364_532# a_1224_652# VNW pfet_05v0 ad=0.3588p pd=1.9u as=0.426p ps=2.08u w=1.38u l=0.5u
X8 a_872_652# D VDD VNW pfet_05v0 ad=0.12p pd=1.24u as=0.44p ps=2.88u w=1u l=0.5u
X9 a_1364_532# a_1020_652# VDD VNW pfet_05v0 ad=0.6072p pd=3.64u as=0.3588p ps=1.9u w=1.38u l=0.5u
X10 a_1020_652# a_504_110# a_872_107# VPW nfet_05v0 ad=0.182p pd=1.22u as=83.99999f ps=0.94u w=0.7u l=0.6u
X11 a_872_107# D VSS VPW nfet_05v0 ad=83.99999f pd=0.94u as=0.308p ps=2.28u w=0.7u l=0.6u
X12 a_1020_652# a_36_92# a_872_652# VNW pfet_05v0 ad=0.26p pd=1.52u as=0.12p ps=1.24u w=1u l=0.5u
X13 a_504_110# a_36_92# VSS VPW nfet_05v0 ad=0.308p pd=2.28u as=0.263p ps=1.49u w=0.7u l=0.6u
X14 a_1364_532# a_1020_652# VSS VPW nfet_05v0 ad=0.3476p pd=2.46u as=0.2054p ps=1.31u w=0.79u l=0.6u
X15 a_1224_652# a_504_110# a_1020_652# VNW pfet_05v0 ad=0.426p pd=2.08u as=0.26p ps=1.52u w=1u l=0.5u
.ends

.subckt DFF_2phase_1$1 VDDd PHI_1 D Q PHI_2 gf180mcu_fd_sc_mcu9t5v0__latq_1$2_1/Q
+ VSSd
Xgf180mcu_fd_sc_mcu9t5v0__latq_1$2_0 gf180mcu_fd_sc_mcu9t5v0__latq_1$2_1/Q PHI_2 Q
+ VDDd VSSd VDDd VSSd gf180mcu_fd_sc_mcu9t5v0__latq_1$2
Xgf180mcu_fd_sc_mcu9t5v0__latq_1$2_1 D PHI_1 gf180mcu_fd_sc_mcu9t5v0__latq_1$2_1/Q
+ VDDd VSSd VDDd VSSd gf180mcu_fd_sc_mcu9t5v0__latq_1$2
.ends

.subckt ShiftReg_row_25 Q[4] Q[5] Q[6] Q[7] Q[8] Q[10] Q[13] Q[16] Q[19] Q[21] Q[22]
+ Q[23] Q[3] Q[2] PHI_2 PHI_1 Q[1] Q[24] Q[9] D_in Q[18] Q[15] Q[12] Q[20] Q[25] Q[17]
+ Q[14] VDDd VSSd DFF_2phase_1$1_0[23]/gf180mcu_fd_sc_mcu9t5v0__latq_1$2_1/Q Q[11]
XDFF_2phase_1$1_0[0] VDDd PHI_1 D_in Q[1] PHI_2 DFF_2phase_1$1_0[0]/gf180mcu_fd_sc_mcu9t5v0__latq_1$2_1/Q
+ VSSd DFF_2phase_1$1
XDFF_2phase_1$1_0[1] VDDd PHI_1 Q[1] Q[2] PHI_2 DFF_2phase_1$1_0[1]/gf180mcu_fd_sc_mcu9t5v0__latq_1$2_1/Q
+ VSSd DFF_2phase_1$1
XDFF_2phase_1$1_0[2] VDDd PHI_1 Q[2] Q[3] PHI_2 DFF_2phase_1$1_0[2]/gf180mcu_fd_sc_mcu9t5v0__latq_1$2_1/Q
+ VSSd DFF_2phase_1$1
XDFF_2phase_1$1_0[3] VDDd PHI_1 Q[3] Q[4] PHI_2 DFF_2phase_1$1_0[3]/gf180mcu_fd_sc_mcu9t5v0__latq_1$2_1/Q
+ VSSd DFF_2phase_1$1
XDFF_2phase_1$1_0[4] VDDd PHI_1 Q[4] Q[5] PHI_2 DFF_2phase_1$1_0[4]/gf180mcu_fd_sc_mcu9t5v0__latq_1$2_1/Q
+ VSSd DFF_2phase_1$1
XDFF_2phase_1$1_0[5] VDDd PHI_1 Q[5] Q[6] PHI_2 DFF_2phase_1$1_0[5]/gf180mcu_fd_sc_mcu9t5v0__latq_1$2_1/Q
+ VSSd DFF_2phase_1$1
XDFF_2phase_1$1_0[6] VDDd PHI_1 Q[6] Q[7] PHI_2 DFF_2phase_1$1_0[6]/gf180mcu_fd_sc_mcu9t5v0__latq_1$2_1/Q
+ VSSd DFF_2phase_1$1
XDFF_2phase_1$1_0[7] VDDd PHI_1 Q[7] Q[8] PHI_2 DFF_2phase_1$1_0[7]/gf180mcu_fd_sc_mcu9t5v0__latq_1$2_1/Q
+ VSSd DFF_2phase_1$1
XDFF_2phase_1$1_0[8] VDDd PHI_1 Q[8] Q[9] PHI_2 DFF_2phase_1$1_0[8]/gf180mcu_fd_sc_mcu9t5v0__latq_1$2_1/Q
+ VSSd DFF_2phase_1$1
XDFF_2phase_1$1_0[9] VDDd PHI_1 Q[9] Q[10] PHI_2 DFF_2phase_1$1_0[9]/gf180mcu_fd_sc_mcu9t5v0__latq_1$2_1/Q
+ VSSd DFF_2phase_1$1
XDFF_2phase_1$1_0[10] VDDd PHI_1 Q[10] Q[11] PHI_2 DFF_2phase_1$1_0[10]/gf180mcu_fd_sc_mcu9t5v0__latq_1$2_1/Q
+ VSSd DFF_2phase_1$1
XDFF_2phase_1$1_0[11] VDDd PHI_1 Q[11] Q[12] PHI_2 DFF_2phase_1$1_0[11]/gf180mcu_fd_sc_mcu9t5v0__latq_1$2_1/Q
+ VSSd DFF_2phase_1$1
XDFF_2phase_1$1_0[12] VDDd PHI_1 Q[12] Q[13] PHI_2 DFF_2phase_1$1_0[12]/gf180mcu_fd_sc_mcu9t5v0__latq_1$2_1/Q
+ VSSd DFF_2phase_1$1
XDFF_2phase_1$1_0[13] VDDd PHI_1 Q[13] Q[14] PHI_2 DFF_2phase_1$1_0[13]/gf180mcu_fd_sc_mcu9t5v0__latq_1$2_1/Q
+ VSSd DFF_2phase_1$1
XDFF_2phase_1$1_0[14] VDDd PHI_1 Q[14] Q[15] PHI_2 DFF_2phase_1$1_0[14]/gf180mcu_fd_sc_mcu9t5v0__latq_1$2_1/Q
+ VSSd DFF_2phase_1$1
XDFF_2phase_1$1_0[15] VDDd PHI_1 Q[15] Q[16] PHI_2 DFF_2phase_1$1_0[15]/gf180mcu_fd_sc_mcu9t5v0__latq_1$2_1/Q
+ VSSd DFF_2phase_1$1
XDFF_2phase_1$1_0[16] VDDd PHI_1 Q[16] Q[17] PHI_2 DFF_2phase_1$1_0[16]/gf180mcu_fd_sc_mcu9t5v0__latq_1$2_1/Q
+ VSSd DFF_2phase_1$1
XDFF_2phase_1$1_0[17] VDDd PHI_1 Q[17] Q[18] PHI_2 DFF_2phase_1$1_0[17]/gf180mcu_fd_sc_mcu9t5v0__latq_1$2_1/Q
+ VSSd DFF_2phase_1$1
XDFF_2phase_1$1_0[18] VDDd PHI_1 Q[18] Q[19] PHI_2 DFF_2phase_1$1_0[18]/gf180mcu_fd_sc_mcu9t5v0__latq_1$2_1/Q
+ VSSd DFF_2phase_1$1
XDFF_2phase_1$1_0[19] VDDd PHI_1 Q[19] Q[20] PHI_2 DFF_2phase_1$1_0[19]/gf180mcu_fd_sc_mcu9t5v0__latq_1$2_1/Q
+ VSSd DFF_2phase_1$1
XDFF_2phase_1$1_0[20] VDDd PHI_1 Q[20] Q[21] PHI_2 DFF_2phase_1$1_0[20]/gf180mcu_fd_sc_mcu9t5v0__latq_1$2_1/Q
+ VSSd DFF_2phase_1$1
XDFF_2phase_1$1_0[21] VDDd PHI_1 Q[21] Q[22] PHI_2 DFF_2phase_1$1_0[21]/gf180mcu_fd_sc_mcu9t5v0__latq_1$2_1/Q
+ VSSd DFF_2phase_1$1
XDFF_2phase_1$1_0[22] VDDd PHI_1 Q[22] Q[23] PHI_2 DFF_2phase_1$1_0[22]/gf180mcu_fd_sc_mcu9t5v0__latq_1$2_1/Q
+ VSSd DFF_2phase_1$1
XDFF_2phase_1$1_0[23] VDDd PHI_1 Q[23] Q[24] PHI_2 DFF_2phase_1$1_0[23]/gf180mcu_fd_sc_mcu9t5v0__latq_1$2_1/Q
+ VSSd DFF_2phase_1$1
XDFF_2phase_1$1_0[24] VDDd PHI_1 Q[24] Q[25] PHI_2 DFF_2phase_1$1_0[24]/gf180mcu_fd_sc_mcu9t5v0__latq_1$2_1/Q
+ VSSd DFF_2phase_1$1
.ends

.subckt gf180mcu_fd_sc_mcu9t5v0__inv_4 I VDD VSS ZN VNW VPW
X0 ZN I VDD VNW pfet_05v0 ad=0.5673p pd=2.45u as=0.5673p ps=2.45u w=1.83u l=0.5u
X1 VSS I ZN VPW nfet_05v0 ad=0.5808p pd=3.52u as=0.3432p ps=1.84u w=1.32u l=0.6u
X2 VSS I ZN VPW nfet_05v0 ad=0.3432p pd=1.84u as=0.3432p ps=1.84u w=1.32u l=0.6u
X3 ZN I VSS VPW nfet_05v0 ad=0.3432p pd=1.84u as=0.3432p ps=1.84u w=1.32u l=0.6u
X4 VDD I ZN VNW pfet_05v0 ad=0.5673p pd=2.45u as=0.5673p ps=2.45u w=1.83u l=0.5u
X5 ZN I VSS VPW nfet_05v0 ad=0.3432p pd=1.84u as=0.5808p ps=3.52u w=1.32u l=0.6u
X6 VDD I ZN VNW pfet_05v0 ad=0.8052p pd=4.54u as=0.5673p ps=2.45u w=1.83u l=0.5u
X7 ZN I VDD VNW pfet_05v0 ad=0.5673p pd=2.45u as=0.8052p ps=4.54u w=1.83u l=0.5u
.ends

.subckt gf180mcu_fd_sc_mcu9t5v0__inv_12 I VDD VSS ZN VNW VPW
X0 ZN I VDD VNW pfet_05v0 ad=0.5673p pd=2.45u as=0.5673p ps=2.45u w=1.83u l=0.5u
X1 VSS I ZN VPW nfet_05v0 ad=0.3432p pd=1.84u as=0.3432p ps=1.84u w=1.32u l=0.6u
X2 ZN I VDD VNW pfet_05v0 ad=0.5673p pd=2.45u as=0.5673p ps=2.45u w=1.83u l=0.5u
X3 VSS I ZN VPW nfet_05v0 ad=0.3432p pd=1.84u as=0.3432p ps=1.84u w=1.32u l=0.6u
X4 VDD I ZN VNW pfet_05v0 ad=0.5673p pd=2.45u as=0.5673p ps=2.45u w=1.83u l=0.5u
X5 ZN I VDD VNW pfet_05v0 ad=0.5673p pd=2.45u as=0.5673p ps=2.45u w=1.83u l=0.5u
X6 VSS I ZN VPW nfet_05v0 ad=0.3432p pd=1.84u as=0.3432p ps=1.84u w=1.32u l=0.6u
X7 ZN I VSS VPW nfet_05v0 ad=0.3432p pd=1.84u as=0.3432p ps=1.84u w=1.32u l=0.6u
X8 VDD I ZN VNW pfet_05v0 ad=0.5673p pd=2.45u as=0.5673p ps=2.45u w=1.83u l=0.5u
X9 ZN I VSS VPW nfet_05v0 ad=0.3432p pd=1.84u as=0.3432p ps=1.84u w=1.32u l=0.6u
X10 VSS I ZN VPW nfet_05v0 ad=0.5808p pd=3.52u as=0.3432p ps=1.84u w=1.32u l=0.6u
X11 VDD I ZN VNW pfet_05v0 ad=0.5673p pd=2.45u as=0.5673p ps=2.45u w=1.83u l=0.5u
X12 VDD I ZN VNW pfet_05v0 ad=0.5673p pd=2.45u as=0.5673p ps=2.45u w=1.83u l=0.5u
X13 ZN I VSS VPW nfet_05v0 ad=0.3432p pd=1.84u as=0.5808p ps=3.52u w=1.32u l=0.6u
X14 ZN I VSS VPW nfet_05v0 ad=0.3432p pd=1.84u as=0.3432p ps=1.84u w=1.32u l=0.6u
X15 ZN I VDD VNW pfet_05v0 ad=0.5673p pd=2.45u as=0.5673p ps=2.45u w=1.83u l=0.5u
X16 VDD I ZN VNW pfet_05v0 ad=0.5673p pd=2.45u as=0.5673p ps=2.45u w=1.83u l=0.5u
X17 ZN I VSS VPW nfet_05v0 ad=0.3432p pd=1.84u as=0.3432p ps=1.84u w=1.32u l=0.6u
X18 VDD I ZN VNW pfet_05v0 ad=0.8052p pd=4.54u as=0.5673p ps=2.45u w=1.83u l=0.5u
X19 ZN I VSS VPW nfet_05v0 ad=0.3432p pd=1.84u as=0.3432p ps=1.84u w=1.32u l=0.6u
X20 ZN I VDD VNW pfet_05v0 ad=0.5673p pd=2.45u as=0.5673p ps=2.45u w=1.83u l=0.5u
X21 ZN I VDD VNW pfet_05v0 ad=0.5673p pd=2.45u as=0.8052p ps=4.54u w=1.83u l=0.5u
X22 VSS I ZN VPW nfet_05v0 ad=0.3432p pd=1.84u as=0.3432p ps=1.84u w=1.32u l=0.6u
X23 VSS I ZN VPW nfet_05v0 ad=0.3432p pd=1.84u as=0.3432p ps=1.84u w=1.32u l=0.6u
.ends

.subckt swmatrix_row_25_w_clkbuf VDDd BUS[24] BUS[21] BUS[19] BUS[17] BUS[16] BUS[15]
+ BUS[13] BUS[12] BUS[10] BUS[9] BUS[7] BUS[6] BUS[4] BUS[3] BUS[1] Q[3] Q[4] Q[5]
+ Q[6] Q[7] Q[8] Q[9] Q[10] Q[11] Q[12] Q[13] Q[14] Q[15] Q[16] Q[17] Q[18] Q[19]
+ Q[20] Q[21] Q[22] Q[23] Q[24] D_out pin Q[1] Q[2] D_in PHI_1 BUS[20] ShiftReg_row_25_0/DFF_2phase_1$1_0[23]/gf180mcu_fd_sc_mcu9t5v0__latq_1$2_1/Q
+ BUS[23] enable BUS[22] BUS[25] PHI_2 BUS[8] BUS[11] BUS[2] BUS[18] VSSd BUS[14]
+ BUS[5]
Xgf180mcu_fd_sc_mcu9t5v0__inv_20_0 gf180mcu_fd_sc_mcu9t5v0__inv_20_0/I VDDd VSSd swmatrix_Tgate_0[9]/enable
+ VDDd VSSd gf180mcu_fd_sc_mcu9t5v0__inv_20
Xgf180mcu_fd_sc_mcu9t5v0__inv_20_1 gf180mcu_fd_sc_mcu9t5v0__inv_20_1/I VDDd VSSd ShiftReg_row_25_0/PHI_2
+ VDDd VSSd gf180mcu_fd_sc_mcu9t5v0__inv_20
Xgf180mcu_fd_sc_mcu9t5v0__inv_20_2 gf180mcu_fd_sc_mcu9t5v0__inv_20_2/I VDDd VSSd ShiftReg_row_25_0/PHI_1
+ VDDd VSSd gf180mcu_fd_sc_mcu9t5v0__inv_20
Xswmatrix_Tgate_0[0] VDDd VSSd swmatrix_Tgate_0[9]/enable pin BUS[25] D_out swmatrix_Tgate
Xswmatrix_Tgate_0[1] VDDd VSSd swmatrix_Tgate_0[9]/enable pin BUS[24] Q[24] swmatrix_Tgate
Xswmatrix_Tgate_0[2] VDDd VSSd swmatrix_Tgate_0[9]/enable pin BUS[23] Q[23] swmatrix_Tgate
Xswmatrix_Tgate_0[3] VDDd VSSd swmatrix_Tgate_0[9]/enable pin BUS[22] Q[22] swmatrix_Tgate
Xswmatrix_Tgate_0[4] VDDd VSSd swmatrix_Tgate_0[9]/enable pin BUS[21] Q[21] swmatrix_Tgate
Xswmatrix_Tgate_0[5] VDDd VSSd swmatrix_Tgate_0[9]/enable pin BUS[20] Q[20] swmatrix_Tgate
Xswmatrix_Tgate_0[6] VDDd VSSd swmatrix_Tgate_0[9]/enable pin BUS[19] Q[19] swmatrix_Tgate
Xswmatrix_Tgate_0[7] VDDd VSSd swmatrix_Tgate_0[9]/enable pin BUS[18] Q[18] swmatrix_Tgate
Xswmatrix_Tgate_0[8] VDDd VSSd swmatrix_Tgate_0[9]/enable pin BUS[17] Q[17] swmatrix_Tgate
Xswmatrix_Tgate_0[9] VDDd VSSd swmatrix_Tgate_0[9]/enable pin BUS[16] Q[16] swmatrix_Tgate
Xswmatrix_Tgate_0[10] VDDd VSSd swmatrix_Tgate_0[9]/enable pin BUS[15] Q[15] swmatrix_Tgate
Xswmatrix_Tgate_0[11] VDDd VSSd swmatrix_Tgate_0[9]/enable pin BUS[14] Q[14] swmatrix_Tgate
Xswmatrix_Tgate_0[12] VDDd VSSd swmatrix_Tgate_0[9]/enable pin BUS[13] Q[13] swmatrix_Tgate
Xswmatrix_Tgate_0[13] VDDd VSSd swmatrix_Tgate_0[9]/enable pin BUS[12] Q[12] swmatrix_Tgate
Xswmatrix_Tgate_0[14] VDDd VSSd swmatrix_Tgate_0[9]/enable pin BUS[11] Q[11] swmatrix_Tgate
Xswmatrix_Tgate_0[15] VDDd VSSd swmatrix_Tgate_0[9]/enable pin BUS[10] Q[10] swmatrix_Tgate
Xswmatrix_Tgate_0[16] VDDd VSSd swmatrix_Tgate_0[9]/enable pin BUS[9] Q[9] swmatrix_Tgate
Xswmatrix_Tgate_0[17] VDDd VSSd swmatrix_Tgate_0[9]/enable pin BUS[8] Q[8] swmatrix_Tgate
Xswmatrix_Tgate_0[18] VDDd VSSd swmatrix_Tgate_0[9]/enable pin BUS[7] Q[7] swmatrix_Tgate
Xswmatrix_Tgate_0[19] VDDd VSSd swmatrix_Tgate_0[9]/enable pin BUS[6] Q[6] swmatrix_Tgate
Xswmatrix_Tgate_0[20] VDDd VSSd swmatrix_Tgate_0[9]/enable pin BUS[5] Q[5] swmatrix_Tgate
Xswmatrix_Tgate_0[21] VDDd VSSd swmatrix_Tgate_0[9]/enable pin BUS[4] Q[4] swmatrix_Tgate
Xswmatrix_Tgate_0[22] VDDd VSSd swmatrix_Tgate_0[9]/enable pin BUS[3] Q[3] swmatrix_Tgate
Xswmatrix_Tgate_0[23] VDDd VSSd swmatrix_Tgate_0[9]/enable pin BUS[2] Q[2] swmatrix_Tgate
Xswmatrix_Tgate_0[24] VDDd VSSd swmatrix_Tgate_0[9]/enable pin BUS[1] Q[1] swmatrix_Tgate
Xgf180mcu_fd_sc_mcu9t5v0__inv_8_0 gf180mcu_fd_sc_mcu9t5v0__inv_8_0/I VDDd VSSd gf180mcu_fd_sc_mcu9t5v0__inv_8_0/ZN
+ VDDd VSSd gf180mcu_fd_sc_mcu9t5v0__inv_8
Xgf180mcu_fd_sc_mcu9t5v0__inv_8_1 gf180mcu_fd_sc_mcu9t5v0__inv_8_1/I VDDd VSSd gf180mcu_fd_sc_mcu9t5v0__inv_8_1/ZN
+ VDDd VSSd gf180mcu_fd_sc_mcu9t5v0__inv_8
Xgf180mcu_fd_sc_mcu9t5v0__inv_8_2 gf180mcu_fd_sc_mcu9t5v0__inv_8_2/I VDDd VSSd gf180mcu_fd_sc_mcu9t5v0__inv_8_2/ZN
+ VDDd VSSd gf180mcu_fd_sc_mcu9t5v0__inv_8
XShiftReg_row_25_0 Q[4] Q[5] Q[6] Q[7] Q[8] Q[10] Q[13] Q[16] Q[19] Q[21] Q[22] Q[23]
+ Q[3] Q[2] ShiftReg_row_25_0/PHI_2 ShiftReg_row_25_0/PHI_1 Q[1] Q[24] Q[9] D_in Q[18]
+ Q[15] Q[12] Q[20] D_out Q[17] Q[14] VDDd VSSd ShiftReg_row_25_0/DFF_2phase_1$1_0[23]/gf180mcu_fd_sc_mcu9t5v0__latq_1$2_1/Q
+ Q[11] ShiftReg_row_25
Xgf180mcu_fd_sc_mcu9t5v0__inv_4_0 enable VDDd VSSd gf180mcu_fd_sc_mcu9t5v0__inv_8_0/I
+ VDDd VSSd gf180mcu_fd_sc_mcu9t5v0__inv_4
Xgf180mcu_fd_sc_mcu9t5v0__inv_4_1 PHI_2 VDDd VSSd gf180mcu_fd_sc_mcu9t5v0__inv_8_1/I
+ VDDd VSSd gf180mcu_fd_sc_mcu9t5v0__inv_4
Xgf180mcu_fd_sc_mcu9t5v0__inv_4_2 PHI_1 VDDd VSSd gf180mcu_fd_sc_mcu9t5v0__inv_8_2/I
+ VDDd VSSd gf180mcu_fd_sc_mcu9t5v0__inv_4
Xgf180mcu_fd_sc_mcu9t5v0__inv_12_0 gf180mcu_fd_sc_mcu9t5v0__inv_8_0/ZN VDDd VSSd gf180mcu_fd_sc_mcu9t5v0__inv_20_0/I
+ VDDd VSSd gf180mcu_fd_sc_mcu9t5v0__inv_12
Xgf180mcu_fd_sc_mcu9t5v0__inv_12_1 gf180mcu_fd_sc_mcu9t5v0__inv_8_1/ZN VDDd VSSd gf180mcu_fd_sc_mcu9t5v0__inv_20_1/I
+ VDDd VSSd gf180mcu_fd_sc_mcu9t5v0__inv_12
Xgf180mcu_fd_sc_mcu9t5v0__inv_12_2 gf180mcu_fd_sc_mcu9t5v0__inv_8_2/ZN VDDd VSSd gf180mcu_fd_sc_mcu9t5v0__inv_20_2/I
+ VDDd VSSd gf180mcu_fd_sc_mcu9t5v0__inv_12
.ends

.subckt swmatrix_25_by_130_no_probe VDDd VSSd data_in PIN[10] PIN[20] PIN[30] PIN[40]
+ PIN[50] PIN[60] PIN[7] PIN[8] PIN[9] PIN[1] PIN[11] PIN[12] PIN[13] PIN[14] PIN[15]
+ PIN[16] PIN[17] PIN[18] PIN[19] PIN[2] PIN[21] PIN[22] PIN[23] PIN[24] PIN[25] PIN[26]
+ PIN[27] PIN[28] PIN[29] PIN[3] PIN[31] PIN[32] PIN[33] PIN[34] PIN[35] PIN[36] PIN[37]
+ PIN[38] PIN[39] PIN[4] PIN[41] PIN[42] PIN[43] PIN[44] PIN[45] PIN[46] PIN[47] PIN[48]
+ PIN[49] PIN[5] PIN[51] PIN[52] PIN[53] PIN[54] PIN[55] PIN[56] PIN[57] PIN[58] PIN[59]
+ PIN[6] PIN[61] PIN[62] PIN[63] PIN[64] PIN[65] PIN[66] PIN[67] PIN[68] PIN[69] PIN[71]
+ PIN[72] PIN[73] PIN[74] PIN[75] PIN[76] PIN[77] PIN[78] PIN[79] PIN[81] PIN[82]
+ PIN[83] PIN[84] PIN[85] PIN[86] PIN[87] PIN[88] PIN[89] PIN[91] PIN[92] PIN[93]
+ PIN[94] PIN[95] PIN[96] PIN[97] PIN[98] PIN[99] PIN[101] PIN[102] PIN[103] PIN[104]
+ PIN[105] PIN[106] PIN[107] PIN[108] PIN[109] PIN[111] PIN[112] PIN[113] PIN[114]
+ PIN[115] PIN[116] PIN[117] PIN[118] PIN[119] PIN[121] PIN[122] PIN[123] PIN[124]
+ PIN[125] PIN[126] PIN[127] PIN[128] PIN[129] PIN[100] PIN[80] PIN[120] PIN[110]
+ PIN[70] PIN[90] PIN[130] D_out BUS[15] BUS[2] BUS[3] BUS[4] BUS[5] BUS[6] BUS[7]
+ BUS[8] BUS[9] BUS[10] BUS[11] BUS[12] BUS[13] BUS[14] BUS[16] BUS[17] BUS[18] BUS[19]
+ BUS[20] BUS[21] BUS[22] BUS[23] BUS[24] BUS[25] enable_in PHI_1_in PHI_2_in BUS[1]
Xswmatrix_row_25_w_clkbuf_0[0] VDDd BUS[24] BUS[21] BUS[19] BUS[17] BUS[16] BUS[15]
+ BUS[13] BUS[12] BUS[10] BUS[9] BUS[7] BUS[6] BUS[4] BUS[3] BUS[1] swmatrix_row_25_w_clkbuf_0[0]/Q[3]
+ swmatrix_row_25_w_clkbuf_0[0]/Q[4] swmatrix_row_25_w_clkbuf_0[0]/Q[5] swmatrix_row_25_w_clkbuf_0[0]/Q[6]
+ swmatrix_row_25_w_clkbuf_0[0]/Q[7] swmatrix_row_25_w_clkbuf_0[0]/Q[8] swmatrix_row_25_w_clkbuf_0[0]/Q[9]
+ swmatrix_row_25_w_clkbuf_0[0]/Q[10] swmatrix_row_25_w_clkbuf_0[0]/Q[11] swmatrix_row_25_w_clkbuf_0[0]/Q[12]
+ swmatrix_row_25_w_clkbuf_0[0]/Q[13] swmatrix_row_25_w_clkbuf_0[0]/Q[14] swmatrix_row_25_w_clkbuf_0[0]/Q[15]
+ swmatrix_row_25_w_clkbuf_0[0]/Q[16] swmatrix_row_25_w_clkbuf_0[0]/Q[17] swmatrix_row_25_w_clkbuf_0[0]/Q[18]
+ swmatrix_row_25_w_clkbuf_0[0]/Q[19] swmatrix_row_25_w_clkbuf_0[0]/Q[20] swmatrix_row_25_w_clkbuf_0[0]/Q[21]
+ swmatrix_row_25_w_clkbuf_0[0]/Q[22] swmatrix_row_25_w_clkbuf_0[0]/Q[23] swmatrix_row_25_w_clkbuf_0[0]/Q[24]
+ D_out PIN[130] swmatrix_row_25_w_clkbuf_0[0]/Q[1] swmatrix_row_25_w_clkbuf_0[0]/Q[2]
+ swmatrix_row_25_w_clkbuf_0[0]/D_in PHI_1_in BUS[20] swmatrix_row_25_w_clkbuf_0[0]/ShiftReg_row_25_0/DFF_2phase_1$1_0[23]/gf180mcu_fd_sc_mcu9t5v0__latq_1$2_1/Q
+ BUS[23] enable_in BUS[22] BUS[25] PHI_2_in BUS[8] BUS[11] BUS[2] BUS[18] VSSd BUS[14]
+ BUS[5] swmatrix_row_25_w_clkbuf
Xswmatrix_row_25_w_clkbuf_0[1] VDDd BUS[24] BUS[21] BUS[19] BUS[17] BUS[16] BUS[15]
+ BUS[13] BUS[12] BUS[10] BUS[9] BUS[7] BUS[6] BUS[4] BUS[3] BUS[1] swmatrix_row_25_w_clkbuf_0[1]/Q[3]
+ swmatrix_row_25_w_clkbuf_0[1]/Q[4] swmatrix_row_25_w_clkbuf_0[1]/Q[5] swmatrix_row_25_w_clkbuf_0[1]/Q[6]
+ swmatrix_row_25_w_clkbuf_0[1]/Q[7] swmatrix_row_25_w_clkbuf_0[1]/Q[8] swmatrix_row_25_w_clkbuf_0[1]/Q[9]
+ swmatrix_row_25_w_clkbuf_0[1]/Q[10] swmatrix_row_25_w_clkbuf_0[1]/Q[11] swmatrix_row_25_w_clkbuf_0[1]/Q[12]
+ swmatrix_row_25_w_clkbuf_0[1]/Q[13] swmatrix_row_25_w_clkbuf_0[1]/Q[14] swmatrix_row_25_w_clkbuf_0[1]/Q[15]
+ swmatrix_row_25_w_clkbuf_0[1]/Q[16] swmatrix_row_25_w_clkbuf_0[1]/Q[17] swmatrix_row_25_w_clkbuf_0[1]/Q[18]
+ swmatrix_row_25_w_clkbuf_0[1]/Q[19] swmatrix_row_25_w_clkbuf_0[1]/Q[20] swmatrix_row_25_w_clkbuf_0[1]/Q[21]
+ swmatrix_row_25_w_clkbuf_0[1]/Q[22] swmatrix_row_25_w_clkbuf_0[1]/Q[23] swmatrix_row_25_w_clkbuf_0[1]/Q[24]
+ swmatrix_row_25_w_clkbuf_0[0]/D_in PIN[129] swmatrix_row_25_w_clkbuf_0[1]/Q[1] swmatrix_row_25_w_clkbuf_0[1]/Q[2]
+ swmatrix_row_25_w_clkbuf_0[1]/D_in PHI_1_in BUS[20] swmatrix_row_25_w_clkbuf_0[1]/ShiftReg_row_25_0/DFF_2phase_1$1_0[23]/gf180mcu_fd_sc_mcu9t5v0__latq_1$2_1/Q
+ BUS[23] enable_in BUS[22] BUS[25] PHI_2_in BUS[8] BUS[11] BUS[2] BUS[18] VSSd BUS[14]
+ BUS[5] swmatrix_row_25_w_clkbuf
Xswmatrix_row_25_w_clkbuf_0[2] VDDd BUS[24] BUS[21] BUS[19] BUS[17] BUS[16] BUS[15]
+ BUS[13] BUS[12] BUS[10] BUS[9] BUS[7] BUS[6] BUS[4] BUS[3] BUS[1] swmatrix_row_25_w_clkbuf_0[2]/Q[3]
+ swmatrix_row_25_w_clkbuf_0[2]/Q[4] swmatrix_row_25_w_clkbuf_0[2]/Q[5] swmatrix_row_25_w_clkbuf_0[2]/Q[6]
+ swmatrix_row_25_w_clkbuf_0[2]/Q[7] swmatrix_row_25_w_clkbuf_0[2]/Q[8] swmatrix_row_25_w_clkbuf_0[2]/Q[9]
+ swmatrix_row_25_w_clkbuf_0[2]/Q[10] swmatrix_row_25_w_clkbuf_0[2]/Q[11] swmatrix_row_25_w_clkbuf_0[2]/Q[12]
+ swmatrix_row_25_w_clkbuf_0[2]/Q[13] swmatrix_row_25_w_clkbuf_0[2]/Q[14] swmatrix_row_25_w_clkbuf_0[2]/Q[15]
+ swmatrix_row_25_w_clkbuf_0[2]/Q[16] swmatrix_row_25_w_clkbuf_0[2]/Q[17] swmatrix_row_25_w_clkbuf_0[2]/Q[18]
+ swmatrix_row_25_w_clkbuf_0[2]/Q[19] swmatrix_row_25_w_clkbuf_0[2]/Q[20] swmatrix_row_25_w_clkbuf_0[2]/Q[21]
+ swmatrix_row_25_w_clkbuf_0[2]/Q[22] swmatrix_row_25_w_clkbuf_0[2]/Q[23] swmatrix_row_25_w_clkbuf_0[2]/Q[24]
+ swmatrix_row_25_w_clkbuf_0[1]/D_in PIN[128] swmatrix_row_25_w_clkbuf_0[2]/Q[1] swmatrix_row_25_w_clkbuf_0[2]/Q[2]
+ swmatrix_row_25_w_clkbuf_0[2]/D_in PHI_1_in BUS[20] swmatrix_row_25_w_clkbuf_0[2]/ShiftReg_row_25_0/DFF_2phase_1$1_0[23]/gf180mcu_fd_sc_mcu9t5v0__latq_1$2_1/Q
+ BUS[23] enable_in BUS[22] BUS[25] PHI_2_in BUS[8] BUS[11] BUS[2] BUS[18] VSSd BUS[14]
+ BUS[5] swmatrix_row_25_w_clkbuf
Xswmatrix_row_25_w_clkbuf_0[3] VDDd BUS[24] BUS[21] BUS[19] BUS[17] BUS[16] BUS[15]
+ BUS[13] BUS[12] BUS[10] BUS[9] BUS[7] BUS[6] BUS[4] BUS[3] BUS[1] swmatrix_row_25_w_clkbuf_0[3]/Q[3]
+ swmatrix_row_25_w_clkbuf_0[3]/Q[4] swmatrix_row_25_w_clkbuf_0[3]/Q[5] swmatrix_row_25_w_clkbuf_0[3]/Q[6]
+ swmatrix_row_25_w_clkbuf_0[3]/Q[7] swmatrix_row_25_w_clkbuf_0[3]/Q[8] swmatrix_row_25_w_clkbuf_0[3]/Q[9]
+ swmatrix_row_25_w_clkbuf_0[3]/Q[10] swmatrix_row_25_w_clkbuf_0[3]/Q[11] swmatrix_row_25_w_clkbuf_0[3]/Q[12]
+ swmatrix_row_25_w_clkbuf_0[3]/Q[13] swmatrix_row_25_w_clkbuf_0[3]/Q[14] swmatrix_row_25_w_clkbuf_0[3]/Q[15]
+ swmatrix_row_25_w_clkbuf_0[3]/Q[16] swmatrix_row_25_w_clkbuf_0[3]/Q[17] swmatrix_row_25_w_clkbuf_0[3]/Q[18]
+ swmatrix_row_25_w_clkbuf_0[3]/Q[19] swmatrix_row_25_w_clkbuf_0[3]/Q[20] swmatrix_row_25_w_clkbuf_0[3]/Q[21]
+ swmatrix_row_25_w_clkbuf_0[3]/Q[22] swmatrix_row_25_w_clkbuf_0[3]/Q[23] swmatrix_row_25_w_clkbuf_0[3]/Q[24]
+ swmatrix_row_25_w_clkbuf_0[2]/D_in PIN[127] swmatrix_row_25_w_clkbuf_0[3]/Q[1] swmatrix_row_25_w_clkbuf_0[3]/Q[2]
+ swmatrix_row_25_w_clkbuf_0[3]/D_in PHI_1_in BUS[20] swmatrix_row_25_w_clkbuf_0[3]/ShiftReg_row_25_0/DFF_2phase_1$1_0[23]/gf180mcu_fd_sc_mcu9t5v0__latq_1$2_1/Q
+ BUS[23] enable_in BUS[22] BUS[25] PHI_2_in BUS[8] BUS[11] BUS[2] BUS[18] VSSd BUS[14]
+ BUS[5] swmatrix_row_25_w_clkbuf
Xswmatrix_row_25_w_clkbuf_0[4] VDDd BUS[24] BUS[21] BUS[19] BUS[17] BUS[16] BUS[15]
+ BUS[13] BUS[12] BUS[10] BUS[9] BUS[7] BUS[6] BUS[4] BUS[3] BUS[1] swmatrix_row_25_w_clkbuf_0[4]/Q[3]
+ swmatrix_row_25_w_clkbuf_0[4]/Q[4] swmatrix_row_25_w_clkbuf_0[4]/Q[5] swmatrix_row_25_w_clkbuf_0[4]/Q[6]
+ swmatrix_row_25_w_clkbuf_0[4]/Q[7] swmatrix_row_25_w_clkbuf_0[4]/Q[8] swmatrix_row_25_w_clkbuf_0[4]/Q[9]
+ swmatrix_row_25_w_clkbuf_0[4]/Q[10] swmatrix_row_25_w_clkbuf_0[4]/Q[11] swmatrix_row_25_w_clkbuf_0[4]/Q[12]
+ swmatrix_row_25_w_clkbuf_0[4]/Q[13] swmatrix_row_25_w_clkbuf_0[4]/Q[14] swmatrix_row_25_w_clkbuf_0[4]/Q[15]
+ swmatrix_row_25_w_clkbuf_0[4]/Q[16] swmatrix_row_25_w_clkbuf_0[4]/Q[17] swmatrix_row_25_w_clkbuf_0[4]/Q[18]
+ swmatrix_row_25_w_clkbuf_0[4]/Q[19] swmatrix_row_25_w_clkbuf_0[4]/Q[20] swmatrix_row_25_w_clkbuf_0[4]/Q[21]
+ swmatrix_row_25_w_clkbuf_0[4]/Q[22] swmatrix_row_25_w_clkbuf_0[4]/Q[23] swmatrix_row_25_w_clkbuf_0[4]/Q[24]
+ swmatrix_row_25_w_clkbuf_0[3]/D_in PIN[126] swmatrix_row_25_w_clkbuf_0[4]/Q[1] swmatrix_row_25_w_clkbuf_0[4]/Q[2]
+ swmatrix_row_25_w_clkbuf_0[4]/D_in PHI_1_in BUS[20] swmatrix_row_25_w_clkbuf_0[4]/ShiftReg_row_25_0/DFF_2phase_1$1_0[23]/gf180mcu_fd_sc_mcu9t5v0__latq_1$2_1/Q
+ BUS[23] enable_in BUS[22] BUS[25] PHI_2_in BUS[8] BUS[11] BUS[2] BUS[18] VSSd BUS[14]
+ BUS[5] swmatrix_row_25_w_clkbuf
Xswmatrix_row_25_w_clkbuf_0[5] VDDd BUS[24] BUS[21] BUS[19] BUS[17] BUS[16] BUS[15]
+ BUS[13] BUS[12] BUS[10] BUS[9] BUS[7] BUS[6] BUS[4] BUS[3] BUS[1] swmatrix_row_25_w_clkbuf_0[5]/Q[3]
+ swmatrix_row_25_w_clkbuf_0[5]/Q[4] swmatrix_row_25_w_clkbuf_0[5]/Q[5] swmatrix_row_25_w_clkbuf_0[5]/Q[6]
+ swmatrix_row_25_w_clkbuf_0[5]/Q[7] swmatrix_row_25_w_clkbuf_0[5]/Q[8] swmatrix_row_25_w_clkbuf_0[5]/Q[9]
+ swmatrix_row_25_w_clkbuf_0[5]/Q[10] swmatrix_row_25_w_clkbuf_0[5]/Q[11] swmatrix_row_25_w_clkbuf_0[5]/Q[12]
+ swmatrix_row_25_w_clkbuf_0[5]/Q[13] swmatrix_row_25_w_clkbuf_0[5]/Q[14] swmatrix_row_25_w_clkbuf_0[5]/Q[15]
+ swmatrix_row_25_w_clkbuf_0[5]/Q[16] swmatrix_row_25_w_clkbuf_0[5]/Q[17] swmatrix_row_25_w_clkbuf_0[5]/Q[18]
+ swmatrix_row_25_w_clkbuf_0[5]/Q[19] swmatrix_row_25_w_clkbuf_0[5]/Q[20] swmatrix_row_25_w_clkbuf_0[5]/Q[21]
+ swmatrix_row_25_w_clkbuf_0[5]/Q[22] swmatrix_row_25_w_clkbuf_0[5]/Q[23] swmatrix_row_25_w_clkbuf_0[5]/Q[24]
+ swmatrix_row_25_w_clkbuf_0[4]/D_in PIN[125] swmatrix_row_25_w_clkbuf_0[5]/Q[1] swmatrix_row_25_w_clkbuf_0[5]/Q[2]
+ swmatrix_row_25_w_clkbuf_0[5]/D_in PHI_1_in BUS[20] swmatrix_row_25_w_clkbuf_0[5]/ShiftReg_row_25_0/DFF_2phase_1$1_0[23]/gf180mcu_fd_sc_mcu9t5v0__latq_1$2_1/Q
+ BUS[23] enable_in BUS[22] BUS[25] PHI_2_in BUS[8] BUS[11] BUS[2] BUS[18] VSSd BUS[14]
+ BUS[5] swmatrix_row_25_w_clkbuf
Xswmatrix_row_25_w_clkbuf_0[6] VDDd BUS[24] BUS[21] BUS[19] BUS[17] BUS[16] BUS[15]
+ BUS[13] BUS[12] BUS[10] BUS[9] BUS[7] BUS[6] BUS[4] BUS[3] BUS[1] swmatrix_row_25_w_clkbuf_0[6]/Q[3]
+ swmatrix_row_25_w_clkbuf_0[6]/Q[4] swmatrix_row_25_w_clkbuf_0[6]/Q[5] swmatrix_row_25_w_clkbuf_0[6]/Q[6]
+ swmatrix_row_25_w_clkbuf_0[6]/Q[7] swmatrix_row_25_w_clkbuf_0[6]/Q[8] swmatrix_row_25_w_clkbuf_0[6]/Q[9]
+ swmatrix_row_25_w_clkbuf_0[6]/Q[10] swmatrix_row_25_w_clkbuf_0[6]/Q[11] swmatrix_row_25_w_clkbuf_0[6]/Q[12]
+ swmatrix_row_25_w_clkbuf_0[6]/Q[13] swmatrix_row_25_w_clkbuf_0[6]/Q[14] swmatrix_row_25_w_clkbuf_0[6]/Q[15]
+ swmatrix_row_25_w_clkbuf_0[6]/Q[16] swmatrix_row_25_w_clkbuf_0[6]/Q[17] swmatrix_row_25_w_clkbuf_0[6]/Q[18]
+ swmatrix_row_25_w_clkbuf_0[6]/Q[19] swmatrix_row_25_w_clkbuf_0[6]/Q[20] swmatrix_row_25_w_clkbuf_0[6]/Q[21]
+ swmatrix_row_25_w_clkbuf_0[6]/Q[22] swmatrix_row_25_w_clkbuf_0[6]/Q[23] swmatrix_row_25_w_clkbuf_0[6]/Q[24]
+ swmatrix_row_25_w_clkbuf_0[5]/D_in PIN[124] swmatrix_row_25_w_clkbuf_0[6]/Q[1] swmatrix_row_25_w_clkbuf_0[6]/Q[2]
+ swmatrix_row_25_w_clkbuf_0[6]/D_in PHI_1_in BUS[20] swmatrix_row_25_w_clkbuf_0[6]/ShiftReg_row_25_0/DFF_2phase_1$1_0[23]/gf180mcu_fd_sc_mcu9t5v0__latq_1$2_1/Q
+ BUS[23] enable_in BUS[22] BUS[25] PHI_2_in BUS[8] BUS[11] BUS[2] BUS[18] VSSd BUS[14]
+ BUS[5] swmatrix_row_25_w_clkbuf
Xswmatrix_row_25_w_clkbuf_0[7] VDDd BUS[24] BUS[21] BUS[19] BUS[17] BUS[16] BUS[15]
+ BUS[13] BUS[12] BUS[10] BUS[9] BUS[7] BUS[6] BUS[4] BUS[3] BUS[1] swmatrix_row_25_w_clkbuf_0[7]/Q[3]
+ swmatrix_row_25_w_clkbuf_0[7]/Q[4] swmatrix_row_25_w_clkbuf_0[7]/Q[5] swmatrix_row_25_w_clkbuf_0[7]/Q[6]
+ swmatrix_row_25_w_clkbuf_0[7]/Q[7] swmatrix_row_25_w_clkbuf_0[7]/Q[8] swmatrix_row_25_w_clkbuf_0[7]/Q[9]
+ swmatrix_row_25_w_clkbuf_0[7]/Q[10] swmatrix_row_25_w_clkbuf_0[7]/Q[11] swmatrix_row_25_w_clkbuf_0[7]/Q[12]
+ swmatrix_row_25_w_clkbuf_0[7]/Q[13] swmatrix_row_25_w_clkbuf_0[7]/Q[14] swmatrix_row_25_w_clkbuf_0[7]/Q[15]
+ swmatrix_row_25_w_clkbuf_0[7]/Q[16] swmatrix_row_25_w_clkbuf_0[7]/Q[17] swmatrix_row_25_w_clkbuf_0[7]/Q[18]
+ swmatrix_row_25_w_clkbuf_0[7]/Q[19] swmatrix_row_25_w_clkbuf_0[7]/Q[20] swmatrix_row_25_w_clkbuf_0[7]/Q[21]
+ swmatrix_row_25_w_clkbuf_0[7]/Q[22] swmatrix_row_25_w_clkbuf_0[7]/Q[23] swmatrix_row_25_w_clkbuf_0[7]/Q[24]
+ swmatrix_row_25_w_clkbuf_0[6]/D_in PIN[123] swmatrix_row_25_w_clkbuf_0[7]/Q[1] swmatrix_row_25_w_clkbuf_0[7]/Q[2]
+ swmatrix_row_25_w_clkbuf_0[7]/D_in PHI_1_in BUS[20] swmatrix_row_25_w_clkbuf_0[7]/ShiftReg_row_25_0/DFF_2phase_1$1_0[23]/gf180mcu_fd_sc_mcu9t5v0__latq_1$2_1/Q
+ BUS[23] enable_in BUS[22] BUS[25] PHI_2_in BUS[8] BUS[11] BUS[2] BUS[18] VSSd BUS[14]
+ BUS[5] swmatrix_row_25_w_clkbuf
Xswmatrix_row_25_w_clkbuf_0[8] VDDd BUS[24] BUS[21] BUS[19] BUS[17] BUS[16] BUS[15]
+ BUS[13] BUS[12] BUS[10] BUS[9] BUS[7] BUS[6] BUS[4] BUS[3] BUS[1] swmatrix_row_25_w_clkbuf_0[8]/Q[3]
+ swmatrix_row_25_w_clkbuf_0[8]/Q[4] swmatrix_row_25_w_clkbuf_0[8]/Q[5] swmatrix_row_25_w_clkbuf_0[8]/Q[6]
+ swmatrix_row_25_w_clkbuf_0[8]/Q[7] swmatrix_row_25_w_clkbuf_0[8]/Q[8] swmatrix_row_25_w_clkbuf_0[8]/Q[9]
+ swmatrix_row_25_w_clkbuf_0[8]/Q[10] swmatrix_row_25_w_clkbuf_0[8]/Q[11] swmatrix_row_25_w_clkbuf_0[8]/Q[12]
+ swmatrix_row_25_w_clkbuf_0[8]/Q[13] swmatrix_row_25_w_clkbuf_0[8]/Q[14] swmatrix_row_25_w_clkbuf_0[8]/Q[15]
+ swmatrix_row_25_w_clkbuf_0[8]/Q[16] swmatrix_row_25_w_clkbuf_0[8]/Q[17] swmatrix_row_25_w_clkbuf_0[8]/Q[18]
+ swmatrix_row_25_w_clkbuf_0[8]/Q[19] swmatrix_row_25_w_clkbuf_0[8]/Q[20] swmatrix_row_25_w_clkbuf_0[8]/Q[21]
+ swmatrix_row_25_w_clkbuf_0[8]/Q[22] swmatrix_row_25_w_clkbuf_0[8]/Q[23] swmatrix_row_25_w_clkbuf_0[8]/Q[24]
+ swmatrix_row_25_w_clkbuf_0[7]/D_in PIN[122] swmatrix_row_25_w_clkbuf_0[8]/Q[1] swmatrix_row_25_w_clkbuf_0[8]/Q[2]
+ swmatrix_row_25_w_clkbuf_0[8]/D_in PHI_1_in BUS[20] swmatrix_row_25_w_clkbuf_0[8]/ShiftReg_row_25_0/DFF_2phase_1$1_0[23]/gf180mcu_fd_sc_mcu9t5v0__latq_1$2_1/Q
+ BUS[23] enable_in BUS[22] BUS[25] PHI_2_in BUS[8] BUS[11] BUS[2] BUS[18] VSSd BUS[14]
+ BUS[5] swmatrix_row_25_w_clkbuf
Xswmatrix_row_25_w_clkbuf_0[9] VDDd BUS[24] BUS[21] BUS[19] BUS[17] BUS[16] BUS[15]
+ BUS[13] BUS[12] BUS[10] BUS[9] BUS[7] BUS[6] BUS[4] BUS[3] BUS[1] swmatrix_row_25_w_clkbuf_0[9]/Q[3]
+ swmatrix_row_25_w_clkbuf_0[9]/Q[4] swmatrix_row_25_w_clkbuf_0[9]/Q[5] swmatrix_row_25_w_clkbuf_0[9]/Q[6]
+ swmatrix_row_25_w_clkbuf_0[9]/Q[7] swmatrix_row_25_w_clkbuf_0[9]/Q[8] swmatrix_row_25_w_clkbuf_0[9]/Q[9]
+ swmatrix_row_25_w_clkbuf_0[9]/Q[10] swmatrix_row_25_w_clkbuf_0[9]/Q[11] swmatrix_row_25_w_clkbuf_0[9]/Q[12]
+ swmatrix_row_25_w_clkbuf_0[9]/Q[13] swmatrix_row_25_w_clkbuf_0[9]/Q[14] swmatrix_row_25_w_clkbuf_0[9]/Q[15]
+ swmatrix_row_25_w_clkbuf_0[9]/Q[16] swmatrix_row_25_w_clkbuf_0[9]/Q[17] swmatrix_row_25_w_clkbuf_0[9]/Q[18]
+ swmatrix_row_25_w_clkbuf_0[9]/Q[19] swmatrix_row_25_w_clkbuf_0[9]/Q[20] swmatrix_row_25_w_clkbuf_0[9]/Q[21]
+ swmatrix_row_25_w_clkbuf_0[9]/Q[22] swmatrix_row_25_w_clkbuf_0[9]/Q[23] swmatrix_row_25_w_clkbuf_0[9]/Q[24]
+ swmatrix_row_25_w_clkbuf_0[8]/D_in PIN[121] swmatrix_row_25_w_clkbuf_0[9]/Q[1] swmatrix_row_25_w_clkbuf_0[9]/Q[2]
+ swmatrix_row_25_w_clkbuf_0[9]/D_in PHI_1_in BUS[20] swmatrix_row_25_w_clkbuf_0[9]/ShiftReg_row_25_0/DFF_2phase_1$1_0[23]/gf180mcu_fd_sc_mcu9t5v0__latq_1$2_1/Q
+ BUS[23] enable_in BUS[22] BUS[25] PHI_2_in BUS[8] BUS[11] BUS[2] BUS[18] VSSd BUS[14]
+ BUS[5] swmatrix_row_25_w_clkbuf
Xswmatrix_row_25_w_clkbuf_0[10] VDDd BUS[24] BUS[21] BUS[19] BUS[17] BUS[16] BUS[15]
+ BUS[13] BUS[12] BUS[10] BUS[9] BUS[7] BUS[6] BUS[4] BUS[3] BUS[1] swmatrix_row_25_w_clkbuf_0[10]/Q[3]
+ swmatrix_row_25_w_clkbuf_0[10]/Q[4] swmatrix_row_25_w_clkbuf_0[10]/Q[5] swmatrix_row_25_w_clkbuf_0[10]/Q[6]
+ swmatrix_row_25_w_clkbuf_0[10]/Q[7] swmatrix_row_25_w_clkbuf_0[10]/Q[8] swmatrix_row_25_w_clkbuf_0[10]/Q[9]
+ swmatrix_row_25_w_clkbuf_0[10]/Q[10] swmatrix_row_25_w_clkbuf_0[10]/Q[11] swmatrix_row_25_w_clkbuf_0[10]/Q[12]
+ swmatrix_row_25_w_clkbuf_0[10]/Q[13] swmatrix_row_25_w_clkbuf_0[10]/Q[14] swmatrix_row_25_w_clkbuf_0[10]/Q[15]
+ swmatrix_row_25_w_clkbuf_0[10]/Q[16] swmatrix_row_25_w_clkbuf_0[10]/Q[17] swmatrix_row_25_w_clkbuf_0[10]/Q[18]
+ swmatrix_row_25_w_clkbuf_0[10]/Q[19] swmatrix_row_25_w_clkbuf_0[10]/Q[20] swmatrix_row_25_w_clkbuf_0[10]/Q[21]
+ swmatrix_row_25_w_clkbuf_0[10]/Q[22] swmatrix_row_25_w_clkbuf_0[10]/Q[23] swmatrix_row_25_w_clkbuf_0[10]/Q[24]
+ swmatrix_row_25_w_clkbuf_0[9]/D_in PIN[120] swmatrix_row_25_w_clkbuf_0[10]/Q[1]
+ swmatrix_row_25_w_clkbuf_0[10]/Q[2] swmatrix_row_25_w_clkbuf_0[10]/D_in PHI_1_in
+ BUS[20] swmatrix_row_25_w_clkbuf_0[10]/ShiftReg_row_25_0/DFF_2phase_1$1_0[23]/gf180mcu_fd_sc_mcu9t5v0__latq_1$2_1/Q
+ BUS[23] enable_in BUS[22] BUS[25] PHI_2_in BUS[8] BUS[11] BUS[2] BUS[18] VSSd BUS[14]
+ BUS[5] swmatrix_row_25_w_clkbuf
Xswmatrix_row_25_w_clkbuf_0[11] VDDd BUS[24] BUS[21] BUS[19] BUS[17] BUS[16] BUS[15]
+ BUS[13] BUS[12] BUS[10] BUS[9] BUS[7] BUS[6] BUS[4] BUS[3] BUS[1] swmatrix_row_25_w_clkbuf_0[11]/Q[3]
+ swmatrix_row_25_w_clkbuf_0[11]/Q[4] swmatrix_row_25_w_clkbuf_0[11]/Q[5] swmatrix_row_25_w_clkbuf_0[11]/Q[6]
+ swmatrix_row_25_w_clkbuf_0[11]/Q[7] swmatrix_row_25_w_clkbuf_0[11]/Q[8] swmatrix_row_25_w_clkbuf_0[11]/Q[9]
+ swmatrix_row_25_w_clkbuf_0[11]/Q[10] swmatrix_row_25_w_clkbuf_0[11]/Q[11] swmatrix_row_25_w_clkbuf_0[11]/Q[12]
+ swmatrix_row_25_w_clkbuf_0[11]/Q[13] swmatrix_row_25_w_clkbuf_0[11]/Q[14] swmatrix_row_25_w_clkbuf_0[11]/Q[15]
+ swmatrix_row_25_w_clkbuf_0[11]/Q[16] swmatrix_row_25_w_clkbuf_0[11]/Q[17] swmatrix_row_25_w_clkbuf_0[11]/Q[18]
+ swmatrix_row_25_w_clkbuf_0[11]/Q[19] swmatrix_row_25_w_clkbuf_0[11]/Q[20] swmatrix_row_25_w_clkbuf_0[11]/Q[21]
+ swmatrix_row_25_w_clkbuf_0[11]/Q[22] swmatrix_row_25_w_clkbuf_0[11]/Q[23] swmatrix_row_25_w_clkbuf_0[11]/Q[24]
+ swmatrix_row_25_w_clkbuf_0[10]/D_in PIN[119] swmatrix_row_25_w_clkbuf_0[11]/Q[1]
+ swmatrix_row_25_w_clkbuf_0[11]/Q[2] swmatrix_row_25_w_clkbuf_0[11]/D_in PHI_1_in
+ BUS[20] swmatrix_row_25_w_clkbuf_0[11]/ShiftReg_row_25_0/DFF_2phase_1$1_0[23]/gf180mcu_fd_sc_mcu9t5v0__latq_1$2_1/Q
+ BUS[23] enable_in BUS[22] BUS[25] PHI_2_in BUS[8] BUS[11] BUS[2] BUS[18] VSSd BUS[14]
+ BUS[5] swmatrix_row_25_w_clkbuf
Xswmatrix_row_25_w_clkbuf_0[12] VDDd BUS[24] BUS[21] BUS[19] BUS[17] BUS[16] BUS[15]
+ BUS[13] BUS[12] BUS[10] BUS[9] BUS[7] BUS[6] BUS[4] BUS[3] BUS[1] swmatrix_row_25_w_clkbuf_0[12]/Q[3]
+ swmatrix_row_25_w_clkbuf_0[12]/Q[4] swmatrix_row_25_w_clkbuf_0[12]/Q[5] swmatrix_row_25_w_clkbuf_0[12]/Q[6]
+ swmatrix_row_25_w_clkbuf_0[12]/Q[7] swmatrix_row_25_w_clkbuf_0[12]/Q[8] swmatrix_row_25_w_clkbuf_0[12]/Q[9]
+ swmatrix_row_25_w_clkbuf_0[12]/Q[10] swmatrix_row_25_w_clkbuf_0[12]/Q[11] swmatrix_row_25_w_clkbuf_0[12]/Q[12]
+ swmatrix_row_25_w_clkbuf_0[12]/Q[13] swmatrix_row_25_w_clkbuf_0[12]/Q[14] swmatrix_row_25_w_clkbuf_0[12]/Q[15]
+ swmatrix_row_25_w_clkbuf_0[12]/Q[16] swmatrix_row_25_w_clkbuf_0[12]/Q[17] swmatrix_row_25_w_clkbuf_0[12]/Q[18]
+ swmatrix_row_25_w_clkbuf_0[12]/Q[19] swmatrix_row_25_w_clkbuf_0[12]/Q[20] swmatrix_row_25_w_clkbuf_0[12]/Q[21]
+ swmatrix_row_25_w_clkbuf_0[12]/Q[22] swmatrix_row_25_w_clkbuf_0[12]/Q[23] swmatrix_row_25_w_clkbuf_0[12]/Q[24]
+ swmatrix_row_25_w_clkbuf_0[11]/D_in PIN[118] swmatrix_row_25_w_clkbuf_0[12]/Q[1]
+ swmatrix_row_25_w_clkbuf_0[12]/Q[2] swmatrix_row_25_w_clkbuf_0[12]/D_in PHI_1_in
+ BUS[20] swmatrix_row_25_w_clkbuf_0[12]/ShiftReg_row_25_0/DFF_2phase_1$1_0[23]/gf180mcu_fd_sc_mcu9t5v0__latq_1$2_1/Q
+ BUS[23] enable_in BUS[22] BUS[25] PHI_2_in BUS[8] BUS[11] BUS[2] BUS[18] VSSd BUS[14]
+ BUS[5] swmatrix_row_25_w_clkbuf
Xswmatrix_row_25_w_clkbuf_0[13] VDDd BUS[24] BUS[21] BUS[19] BUS[17] BUS[16] BUS[15]
+ BUS[13] BUS[12] BUS[10] BUS[9] BUS[7] BUS[6] BUS[4] BUS[3] BUS[1] swmatrix_row_25_w_clkbuf_0[13]/Q[3]
+ swmatrix_row_25_w_clkbuf_0[13]/Q[4] swmatrix_row_25_w_clkbuf_0[13]/Q[5] swmatrix_row_25_w_clkbuf_0[13]/Q[6]
+ swmatrix_row_25_w_clkbuf_0[13]/Q[7] swmatrix_row_25_w_clkbuf_0[13]/Q[8] swmatrix_row_25_w_clkbuf_0[13]/Q[9]
+ swmatrix_row_25_w_clkbuf_0[13]/Q[10] swmatrix_row_25_w_clkbuf_0[13]/Q[11] swmatrix_row_25_w_clkbuf_0[13]/Q[12]
+ swmatrix_row_25_w_clkbuf_0[13]/Q[13] swmatrix_row_25_w_clkbuf_0[13]/Q[14] swmatrix_row_25_w_clkbuf_0[13]/Q[15]
+ swmatrix_row_25_w_clkbuf_0[13]/Q[16] swmatrix_row_25_w_clkbuf_0[13]/Q[17] swmatrix_row_25_w_clkbuf_0[13]/Q[18]
+ swmatrix_row_25_w_clkbuf_0[13]/Q[19] swmatrix_row_25_w_clkbuf_0[13]/Q[20] swmatrix_row_25_w_clkbuf_0[13]/Q[21]
+ swmatrix_row_25_w_clkbuf_0[13]/Q[22] swmatrix_row_25_w_clkbuf_0[13]/Q[23] swmatrix_row_25_w_clkbuf_0[13]/Q[24]
+ swmatrix_row_25_w_clkbuf_0[12]/D_in PIN[117] swmatrix_row_25_w_clkbuf_0[13]/Q[1]
+ swmatrix_row_25_w_clkbuf_0[13]/Q[2] swmatrix_row_25_w_clkbuf_0[13]/D_in PHI_1_in
+ BUS[20] swmatrix_row_25_w_clkbuf_0[13]/ShiftReg_row_25_0/DFF_2phase_1$1_0[23]/gf180mcu_fd_sc_mcu9t5v0__latq_1$2_1/Q
+ BUS[23] enable_in BUS[22] BUS[25] PHI_2_in BUS[8] BUS[11] BUS[2] BUS[18] VSSd BUS[14]
+ BUS[5] swmatrix_row_25_w_clkbuf
Xswmatrix_row_25_w_clkbuf_0[14] VDDd BUS[24] BUS[21] BUS[19] BUS[17] BUS[16] BUS[15]
+ BUS[13] BUS[12] BUS[10] BUS[9] BUS[7] BUS[6] BUS[4] BUS[3] BUS[1] swmatrix_row_25_w_clkbuf_0[14]/Q[3]
+ swmatrix_row_25_w_clkbuf_0[14]/Q[4] swmatrix_row_25_w_clkbuf_0[14]/Q[5] swmatrix_row_25_w_clkbuf_0[14]/Q[6]
+ swmatrix_row_25_w_clkbuf_0[14]/Q[7] swmatrix_row_25_w_clkbuf_0[14]/Q[8] swmatrix_row_25_w_clkbuf_0[14]/Q[9]
+ swmatrix_row_25_w_clkbuf_0[14]/Q[10] swmatrix_row_25_w_clkbuf_0[14]/Q[11] swmatrix_row_25_w_clkbuf_0[14]/Q[12]
+ swmatrix_row_25_w_clkbuf_0[14]/Q[13] swmatrix_row_25_w_clkbuf_0[14]/Q[14] swmatrix_row_25_w_clkbuf_0[14]/Q[15]
+ swmatrix_row_25_w_clkbuf_0[14]/Q[16] swmatrix_row_25_w_clkbuf_0[14]/Q[17] swmatrix_row_25_w_clkbuf_0[14]/Q[18]
+ swmatrix_row_25_w_clkbuf_0[14]/Q[19] swmatrix_row_25_w_clkbuf_0[14]/Q[20] swmatrix_row_25_w_clkbuf_0[14]/Q[21]
+ swmatrix_row_25_w_clkbuf_0[14]/Q[22] swmatrix_row_25_w_clkbuf_0[14]/Q[23] swmatrix_row_25_w_clkbuf_0[14]/Q[24]
+ swmatrix_row_25_w_clkbuf_0[13]/D_in PIN[116] swmatrix_row_25_w_clkbuf_0[14]/Q[1]
+ swmatrix_row_25_w_clkbuf_0[14]/Q[2] swmatrix_row_25_w_clkbuf_0[14]/D_in PHI_1_in
+ BUS[20] swmatrix_row_25_w_clkbuf_0[14]/ShiftReg_row_25_0/DFF_2phase_1$1_0[23]/gf180mcu_fd_sc_mcu9t5v0__latq_1$2_1/Q
+ BUS[23] enable_in BUS[22] BUS[25] PHI_2_in BUS[8] BUS[11] BUS[2] BUS[18] VSSd BUS[14]
+ BUS[5] swmatrix_row_25_w_clkbuf
Xswmatrix_row_25_w_clkbuf_0[15] VDDd BUS[24] BUS[21] BUS[19] BUS[17] BUS[16] BUS[15]
+ BUS[13] BUS[12] BUS[10] BUS[9] BUS[7] BUS[6] BUS[4] BUS[3] BUS[1] swmatrix_row_25_w_clkbuf_0[15]/Q[3]
+ swmatrix_row_25_w_clkbuf_0[15]/Q[4] swmatrix_row_25_w_clkbuf_0[15]/Q[5] swmatrix_row_25_w_clkbuf_0[15]/Q[6]
+ swmatrix_row_25_w_clkbuf_0[15]/Q[7] swmatrix_row_25_w_clkbuf_0[15]/Q[8] swmatrix_row_25_w_clkbuf_0[15]/Q[9]
+ swmatrix_row_25_w_clkbuf_0[15]/Q[10] swmatrix_row_25_w_clkbuf_0[15]/Q[11] swmatrix_row_25_w_clkbuf_0[15]/Q[12]
+ swmatrix_row_25_w_clkbuf_0[15]/Q[13] swmatrix_row_25_w_clkbuf_0[15]/Q[14] swmatrix_row_25_w_clkbuf_0[15]/Q[15]
+ swmatrix_row_25_w_clkbuf_0[15]/Q[16] swmatrix_row_25_w_clkbuf_0[15]/Q[17] swmatrix_row_25_w_clkbuf_0[15]/Q[18]
+ swmatrix_row_25_w_clkbuf_0[15]/Q[19] swmatrix_row_25_w_clkbuf_0[15]/Q[20] swmatrix_row_25_w_clkbuf_0[15]/Q[21]
+ swmatrix_row_25_w_clkbuf_0[15]/Q[22] swmatrix_row_25_w_clkbuf_0[15]/Q[23] swmatrix_row_25_w_clkbuf_0[15]/Q[24]
+ swmatrix_row_25_w_clkbuf_0[14]/D_in PIN[115] swmatrix_row_25_w_clkbuf_0[15]/Q[1]
+ swmatrix_row_25_w_clkbuf_0[15]/Q[2] swmatrix_row_25_w_clkbuf_0[15]/D_in PHI_1_in
+ BUS[20] swmatrix_row_25_w_clkbuf_0[15]/ShiftReg_row_25_0/DFF_2phase_1$1_0[23]/gf180mcu_fd_sc_mcu9t5v0__latq_1$2_1/Q
+ BUS[23] enable_in BUS[22] BUS[25] PHI_2_in BUS[8] BUS[11] BUS[2] BUS[18] VSSd BUS[14]
+ BUS[5] swmatrix_row_25_w_clkbuf
Xswmatrix_row_25_w_clkbuf_0[16] VDDd BUS[24] BUS[21] BUS[19] BUS[17] BUS[16] BUS[15]
+ BUS[13] BUS[12] BUS[10] BUS[9] BUS[7] BUS[6] BUS[4] BUS[3] BUS[1] swmatrix_row_25_w_clkbuf_0[16]/Q[3]
+ swmatrix_row_25_w_clkbuf_0[16]/Q[4] swmatrix_row_25_w_clkbuf_0[16]/Q[5] swmatrix_row_25_w_clkbuf_0[16]/Q[6]
+ swmatrix_row_25_w_clkbuf_0[16]/Q[7] swmatrix_row_25_w_clkbuf_0[16]/Q[8] swmatrix_row_25_w_clkbuf_0[16]/Q[9]
+ swmatrix_row_25_w_clkbuf_0[16]/Q[10] swmatrix_row_25_w_clkbuf_0[16]/Q[11] swmatrix_row_25_w_clkbuf_0[16]/Q[12]
+ swmatrix_row_25_w_clkbuf_0[16]/Q[13] swmatrix_row_25_w_clkbuf_0[16]/Q[14] swmatrix_row_25_w_clkbuf_0[16]/Q[15]
+ swmatrix_row_25_w_clkbuf_0[16]/Q[16] swmatrix_row_25_w_clkbuf_0[16]/Q[17] swmatrix_row_25_w_clkbuf_0[16]/Q[18]
+ swmatrix_row_25_w_clkbuf_0[16]/Q[19] swmatrix_row_25_w_clkbuf_0[16]/Q[20] swmatrix_row_25_w_clkbuf_0[16]/Q[21]
+ swmatrix_row_25_w_clkbuf_0[16]/Q[22] swmatrix_row_25_w_clkbuf_0[16]/Q[23] swmatrix_row_25_w_clkbuf_0[16]/Q[24]
+ swmatrix_row_25_w_clkbuf_0[15]/D_in PIN[114] swmatrix_row_25_w_clkbuf_0[16]/Q[1]
+ swmatrix_row_25_w_clkbuf_0[16]/Q[2] swmatrix_row_25_w_clkbuf_0[16]/D_in PHI_1_in
+ BUS[20] swmatrix_row_25_w_clkbuf_0[16]/ShiftReg_row_25_0/DFF_2phase_1$1_0[23]/gf180mcu_fd_sc_mcu9t5v0__latq_1$2_1/Q
+ BUS[23] enable_in BUS[22] BUS[25] PHI_2_in BUS[8] BUS[11] BUS[2] BUS[18] VSSd BUS[14]
+ BUS[5] swmatrix_row_25_w_clkbuf
Xswmatrix_row_25_w_clkbuf_0[17] VDDd BUS[24] BUS[21] BUS[19] BUS[17] BUS[16] BUS[15]
+ BUS[13] BUS[12] BUS[10] BUS[9] BUS[7] BUS[6] BUS[4] BUS[3] BUS[1] swmatrix_row_25_w_clkbuf_0[17]/Q[3]
+ swmatrix_row_25_w_clkbuf_0[17]/Q[4] swmatrix_row_25_w_clkbuf_0[17]/Q[5] swmatrix_row_25_w_clkbuf_0[17]/Q[6]
+ swmatrix_row_25_w_clkbuf_0[17]/Q[7] swmatrix_row_25_w_clkbuf_0[17]/Q[8] swmatrix_row_25_w_clkbuf_0[17]/Q[9]
+ swmatrix_row_25_w_clkbuf_0[17]/Q[10] swmatrix_row_25_w_clkbuf_0[17]/Q[11] swmatrix_row_25_w_clkbuf_0[17]/Q[12]
+ swmatrix_row_25_w_clkbuf_0[17]/Q[13] swmatrix_row_25_w_clkbuf_0[17]/Q[14] swmatrix_row_25_w_clkbuf_0[17]/Q[15]
+ swmatrix_row_25_w_clkbuf_0[17]/Q[16] swmatrix_row_25_w_clkbuf_0[17]/Q[17] swmatrix_row_25_w_clkbuf_0[17]/Q[18]
+ swmatrix_row_25_w_clkbuf_0[17]/Q[19] swmatrix_row_25_w_clkbuf_0[17]/Q[20] swmatrix_row_25_w_clkbuf_0[17]/Q[21]
+ swmatrix_row_25_w_clkbuf_0[17]/Q[22] swmatrix_row_25_w_clkbuf_0[17]/Q[23] swmatrix_row_25_w_clkbuf_0[17]/Q[24]
+ swmatrix_row_25_w_clkbuf_0[16]/D_in PIN[113] swmatrix_row_25_w_clkbuf_0[17]/Q[1]
+ swmatrix_row_25_w_clkbuf_0[17]/Q[2] swmatrix_row_25_w_clkbuf_0[17]/D_in PHI_1_in
+ BUS[20] swmatrix_row_25_w_clkbuf_0[17]/ShiftReg_row_25_0/DFF_2phase_1$1_0[23]/gf180mcu_fd_sc_mcu9t5v0__latq_1$2_1/Q
+ BUS[23] enable_in BUS[22] BUS[25] PHI_2_in BUS[8] BUS[11] BUS[2] BUS[18] VSSd BUS[14]
+ BUS[5] swmatrix_row_25_w_clkbuf
Xswmatrix_row_25_w_clkbuf_0[18] VDDd BUS[24] BUS[21] BUS[19] BUS[17] BUS[16] BUS[15]
+ BUS[13] BUS[12] BUS[10] BUS[9] BUS[7] BUS[6] BUS[4] BUS[3] BUS[1] swmatrix_row_25_w_clkbuf_0[18]/Q[3]
+ swmatrix_row_25_w_clkbuf_0[18]/Q[4] swmatrix_row_25_w_clkbuf_0[18]/Q[5] swmatrix_row_25_w_clkbuf_0[18]/Q[6]
+ swmatrix_row_25_w_clkbuf_0[18]/Q[7] swmatrix_row_25_w_clkbuf_0[18]/Q[8] swmatrix_row_25_w_clkbuf_0[18]/Q[9]
+ swmatrix_row_25_w_clkbuf_0[18]/Q[10] swmatrix_row_25_w_clkbuf_0[18]/Q[11] swmatrix_row_25_w_clkbuf_0[18]/Q[12]
+ swmatrix_row_25_w_clkbuf_0[18]/Q[13] swmatrix_row_25_w_clkbuf_0[18]/Q[14] swmatrix_row_25_w_clkbuf_0[18]/Q[15]
+ swmatrix_row_25_w_clkbuf_0[18]/Q[16] swmatrix_row_25_w_clkbuf_0[18]/Q[17] swmatrix_row_25_w_clkbuf_0[18]/Q[18]
+ swmatrix_row_25_w_clkbuf_0[18]/Q[19] swmatrix_row_25_w_clkbuf_0[18]/Q[20] swmatrix_row_25_w_clkbuf_0[18]/Q[21]
+ swmatrix_row_25_w_clkbuf_0[18]/Q[22] swmatrix_row_25_w_clkbuf_0[18]/Q[23] swmatrix_row_25_w_clkbuf_0[18]/Q[24]
+ swmatrix_row_25_w_clkbuf_0[17]/D_in PIN[112] swmatrix_row_25_w_clkbuf_0[18]/Q[1]
+ swmatrix_row_25_w_clkbuf_0[18]/Q[2] swmatrix_row_25_w_clkbuf_0[18]/D_in PHI_1_in
+ BUS[20] swmatrix_row_25_w_clkbuf_0[18]/ShiftReg_row_25_0/DFF_2phase_1$1_0[23]/gf180mcu_fd_sc_mcu9t5v0__latq_1$2_1/Q
+ BUS[23] enable_in BUS[22] BUS[25] PHI_2_in BUS[8] BUS[11] BUS[2] BUS[18] VSSd BUS[14]
+ BUS[5] swmatrix_row_25_w_clkbuf
Xswmatrix_row_25_w_clkbuf_0[19] VDDd BUS[24] BUS[21] BUS[19] BUS[17] BUS[16] BUS[15]
+ BUS[13] BUS[12] BUS[10] BUS[9] BUS[7] BUS[6] BUS[4] BUS[3] BUS[1] swmatrix_row_25_w_clkbuf_0[19]/Q[3]
+ swmatrix_row_25_w_clkbuf_0[19]/Q[4] swmatrix_row_25_w_clkbuf_0[19]/Q[5] swmatrix_row_25_w_clkbuf_0[19]/Q[6]
+ swmatrix_row_25_w_clkbuf_0[19]/Q[7] swmatrix_row_25_w_clkbuf_0[19]/Q[8] swmatrix_row_25_w_clkbuf_0[19]/Q[9]
+ swmatrix_row_25_w_clkbuf_0[19]/Q[10] swmatrix_row_25_w_clkbuf_0[19]/Q[11] swmatrix_row_25_w_clkbuf_0[19]/Q[12]
+ swmatrix_row_25_w_clkbuf_0[19]/Q[13] swmatrix_row_25_w_clkbuf_0[19]/Q[14] swmatrix_row_25_w_clkbuf_0[19]/Q[15]
+ swmatrix_row_25_w_clkbuf_0[19]/Q[16] swmatrix_row_25_w_clkbuf_0[19]/Q[17] swmatrix_row_25_w_clkbuf_0[19]/Q[18]
+ swmatrix_row_25_w_clkbuf_0[19]/Q[19] swmatrix_row_25_w_clkbuf_0[19]/Q[20] swmatrix_row_25_w_clkbuf_0[19]/Q[21]
+ swmatrix_row_25_w_clkbuf_0[19]/Q[22] swmatrix_row_25_w_clkbuf_0[19]/Q[23] swmatrix_row_25_w_clkbuf_0[19]/Q[24]
+ swmatrix_row_25_w_clkbuf_0[18]/D_in PIN[111] swmatrix_row_25_w_clkbuf_0[19]/Q[1]
+ swmatrix_row_25_w_clkbuf_0[19]/Q[2] swmatrix_row_25_w_clkbuf_0[19]/D_in PHI_1_in
+ BUS[20] swmatrix_row_25_w_clkbuf_0[19]/ShiftReg_row_25_0/DFF_2phase_1$1_0[23]/gf180mcu_fd_sc_mcu9t5v0__latq_1$2_1/Q
+ BUS[23] enable_in BUS[22] BUS[25] PHI_2_in BUS[8] BUS[11] BUS[2] BUS[18] VSSd BUS[14]
+ BUS[5] swmatrix_row_25_w_clkbuf
Xswmatrix_row_25_w_clkbuf_0[20] VDDd BUS[24] BUS[21] BUS[19] BUS[17] BUS[16] BUS[15]
+ BUS[13] BUS[12] BUS[10] BUS[9] BUS[7] BUS[6] BUS[4] BUS[3] BUS[1] swmatrix_row_25_w_clkbuf_0[20]/Q[3]
+ swmatrix_row_25_w_clkbuf_0[20]/Q[4] swmatrix_row_25_w_clkbuf_0[20]/Q[5] swmatrix_row_25_w_clkbuf_0[20]/Q[6]
+ swmatrix_row_25_w_clkbuf_0[20]/Q[7] swmatrix_row_25_w_clkbuf_0[20]/Q[8] swmatrix_row_25_w_clkbuf_0[20]/Q[9]
+ swmatrix_row_25_w_clkbuf_0[20]/Q[10] swmatrix_row_25_w_clkbuf_0[20]/Q[11] swmatrix_row_25_w_clkbuf_0[20]/Q[12]
+ swmatrix_row_25_w_clkbuf_0[20]/Q[13] swmatrix_row_25_w_clkbuf_0[20]/Q[14] swmatrix_row_25_w_clkbuf_0[20]/Q[15]
+ swmatrix_row_25_w_clkbuf_0[20]/Q[16] swmatrix_row_25_w_clkbuf_0[20]/Q[17] swmatrix_row_25_w_clkbuf_0[20]/Q[18]
+ swmatrix_row_25_w_clkbuf_0[20]/Q[19] swmatrix_row_25_w_clkbuf_0[20]/Q[20] swmatrix_row_25_w_clkbuf_0[20]/Q[21]
+ swmatrix_row_25_w_clkbuf_0[20]/Q[22] swmatrix_row_25_w_clkbuf_0[20]/Q[23] swmatrix_row_25_w_clkbuf_0[20]/Q[24]
+ swmatrix_row_25_w_clkbuf_0[19]/D_in PIN[110] swmatrix_row_25_w_clkbuf_0[20]/Q[1]
+ swmatrix_row_25_w_clkbuf_0[20]/Q[2] swmatrix_row_25_w_clkbuf_0[20]/D_in PHI_1_in
+ BUS[20] swmatrix_row_25_w_clkbuf_0[20]/ShiftReg_row_25_0/DFF_2phase_1$1_0[23]/gf180mcu_fd_sc_mcu9t5v0__latq_1$2_1/Q
+ BUS[23] enable_in BUS[22] BUS[25] PHI_2_in BUS[8] BUS[11] BUS[2] BUS[18] VSSd BUS[14]
+ BUS[5] swmatrix_row_25_w_clkbuf
Xswmatrix_row_25_w_clkbuf_0[21] VDDd BUS[24] BUS[21] BUS[19] BUS[17] BUS[16] BUS[15]
+ BUS[13] BUS[12] BUS[10] BUS[9] BUS[7] BUS[6] BUS[4] BUS[3] BUS[1] swmatrix_row_25_w_clkbuf_0[21]/Q[3]
+ swmatrix_row_25_w_clkbuf_0[21]/Q[4] swmatrix_row_25_w_clkbuf_0[21]/Q[5] swmatrix_row_25_w_clkbuf_0[21]/Q[6]
+ swmatrix_row_25_w_clkbuf_0[21]/Q[7] swmatrix_row_25_w_clkbuf_0[21]/Q[8] swmatrix_row_25_w_clkbuf_0[21]/Q[9]
+ swmatrix_row_25_w_clkbuf_0[21]/Q[10] swmatrix_row_25_w_clkbuf_0[21]/Q[11] swmatrix_row_25_w_clkbuf_0[21]/Q[12]
+ swmatrix_row_25_w_clkbuf_0[21]/Q[13] swmatrix_row_25_w_clkbuf_0[21]/Q[14] swmatrix_row_25_w_clkbuf_0[21]/Q[15]
+ swmatrix_row_25_w_clkbuf_0[21]/Q[16] swmatrix_row_25_w_clkbuf_0[21]/Q[17] swmatrix_row_25_w_clkbuf_0[21]/Q[18]
+ swmatrix_row_25_w_clkbuf_0[21]/Q[19] swmatrix_row_25_w_clkbuf_0[21]/Q[20] swmatrix_row_25_w_clkbuf_0[21]/Q[21]
+ swmatrix_row_25_w_clkbuf_0[21]/Q[22] swmatrix_row_25_w_clkbuf_0[21]/Q[23] swmatrix_row_25_w_clkbuf_0[21]/Q[24]
+ swmatrix_row_25_w_clkbuf_0[20]/D_in PIN[109] swmatrix_row_25_w_clkbuf_0[21]/Q[1]
+ swmatrix_row_25_w_clkbuf_0[21]/Q[2] swmatrix_row_25_w_clkbuf_0[21]/D_in PHI_1_in
+ BUS[20] swmatrix_row_25_w_clkbuf_0[21]/ShiftReg_row_25_0/DFF_2phase_1$1_0[23]/gf180mcu_fd_sc_mcu9t5v0__latq_1$2_1/Q
+ BUS[23] enable_in BUS[22] BUS[25] PHI_2_in BUS[8] BUS[11] BUS[2] BUS[18] VSSd BUS[14]
+ BUS[5] swmatrix_row_25_w_clkbuf
Xswmatrix_row_25_w_clkbuf_0[22] VDDd BUS[24] BUS[21] BUS[19] BUS[17] BUS[16] BUS[15]
+ BUS[13] BUS[12] BUS[10] BUS[9] BUS[7] BUS[6] BUS[4] BUS[3] BUS[1] swmatrix_row_25_w_clkbuf_0[22]/Q[3]
+ swmatrix_row_25_w_clkbuf_0[22]/Q[4] swmatrix_row_25_w_clkbuf_0[22]/Q[5] swmatrix_row_25_w_clkbuf_0[22]/Q[6]
+ swmatrix_row_25_w_clkbuf_0[22]/Q[7] swmatrix_row_25_w_clkbuf_0[22]/Q[8] swmatrix_row_25_w_clkbuf_0[22]/Q[9]
+ swmatrix_row_25_w_clkbuf_0[22]/Q[10] swmatrix_row_25_w_clkbuf_0[22]/Q[11] swmatrix_row_25_w_clkbuf_0[22]/Q[12]
+ swmatrix_row_25_w_clkbuf_0[22]/Q[13] swmatrix_row_25_w_clkbuf_0[22]/Q[14] swmatrix_row_25_w_clkbuf_0[22]/Q[15]
+ swmatrix_row_25_w_clkbuf_0[22]/Q[16] swmatrix_row_25_w_clkbuf_0[22]/Q[17] swmatrix_row_25_w_clkbuf_0[22]/Q[18]
+ swmatrix_row_25_w_clkbuf_0[22]/Q[19] swmatrix_row_25_w_clkbuf_0[22]/Q[20] swmatrix_row_25_w_clkbuf_0[22]/Q[21]
+ swmatrix_row_25_w_clkbuf_0[22]/Q[22] swmatrix_row_25_w_clkbuf_0[22]/Q[23] swmatrix_row_25_w_clkbuf_0[22]/Q[24]
+ swmatrix_row_25_w_clkbuf_0[21]/D_in PIN[108] swmatrix_row_25_w_clkbuf_0[22]/Q[1]
+ swmatrix_row_25_w_clkbuf_0[22]/Q[2] swmatrix_row_25_w_clkbuf_0[22]/D_in PHI_1_in
+ BUS[20] swmatrix_row_25_w_clkbuf_0[22]/ShiftReg_row_25_0/DFF_2phase_1$1_0[23]/gf180mcu_fd_sc_mcu9t5v0__latq_1$2_1/Q
+ BUS[23] enable_in BUS[22] BUS[25] PHI_2_in BUS[8] BUS[11] BUS[2] BUS[18] VSSd BUS[14]
+ BUS[5] swmatrix_row_25_w_clkbuf
Xswmatrix_row_25_w_clkbuf_0[23] VDDd BUS[24] BUS[21] BUS[19] BUS[17] BUS[16] BUS[15]
+ BUS[13] BUS[12] BUS[10] BUS[9] BUS[7] BUS[6] BUS[4] BUS[3] BUS[1] swmatrix_row_25_w_clkbuf_0[23]/Q[3]
+ swmatrix_row_25_w_clkbuf_0[23]/Q[4] swmatrix_row_25_w_clkbuf_0[23]/Q[5] swmatrix_row_25_w_clkbuf_0[23]/Q[6]
+ swmatrix_row_25_w_clkbuf_0[23]/Q[7] swmatrix_row_25_w_clkbuf_0[23]/Q[8] swmatrix_row_25_w_clkbuf_0[23]/Q[9]
+ swmatrix_row_25_w_clkbuf_0[23]/Q[10] swmatrix_row_25_w_clkbuf_0[23]/Q[11] swmatrix_row_25_w_clkbuf_0[23]/Q[12]
+ swmatrix_row_25_w_clkbuf_0[23]/Q[13] swmatrix_row_25_w_clkbuf_0[23]/Q[14] swmatrix_row_25_w_clkbuf_0[23]/Q[15]
+ swmatrix_row_25_w_clkbuf_0[23]/Q[16] swmatrix_row_25_w_clkbuf_0[23]/Q[17] swmatrix_row_25_w_clkbuf_0[23]/Q[18]
+ swmatrix_row_25_w_clkbuf_0[23]/Q[19] swmatrix_row_25_w_clkbuf_0[23]/Q[20] swmatrix_row_25_w_clkbuf_0[23]/Q[21]
+ swmatrix_row_25_w_clkbuf_0[23]/Q[22] swmatrix_row_25_w_clkbuf_0[23]/Q[23] swmatrix_row_25_w_clkbuf_0[23]/Q[24]
+ swmatrix_row_25_w_clkbuf_0[22]/D_in PIN[107] swmatrix_row_25_w_clkbuf_0[23]/Q[1]
+ swmatrix_row_25_w_clkbuf_0[23]/Q[2] swmatrix_row_25_w_clkbuf_0[23]/D_in PHI_1_in
+ BUS[20] swmatrix_row_25_w_clkbuf_0[23]/ShiftReg_row_25_0/DFF_2phase_1$1_0[23]/gf180mcu_fd_sc_mcu9t5v0__latq_1$2_1/Q
+ BUS[23] enable_in BUS[22] BUS[25] PHI_2_in BUS[8] BUS[11] BUS[2] BUS[18] VSSd BUS[14]
+ BUS[5] swmatrix_row_25_w_clkbuf
Xswmatrix_row_25_w_clkbuf_0[24] VDDd BUS[24] BUS[21] BUS[19] BUS[17] BUS[16] BUS[15]
+ BUS[13] BUS[12] BUS[10] BUS[9] BUS[7] BUS[6] BUS[4] BUS[3] BUS[1] swmatrix_row_25_w_clkbuf_0[24]/Q[3]
+ swmatrix_row_25_w_clkbuf_0[24]/Q[4] swmatrix_row_25_w_clkbuf_0[24]/Q[5] swmatrix_row_25_w_clkbuf_0[24]/Q[6]
+ swmatrix_row_25_w_clkbuf_0[24]/Q[7] swmatrix_row_25_w_clkbuf_0[24]/Q[8] swmatrix_row_25_w_clkbuf_0[24]/Q[9]
+ swmatrix_row_25_w_clkbuf_0[24]/Q[10] swmatrix_row_25_w_clkbuf_0[24]/Q[11] swmatrix_row_25_w_clkbuf_0[24]/Q[12]
+ swmatrix_row_25_w_clkbuf_0[24]/Q[13] swmatrix_row_25_w_clkbuf_0[24]/Q[14] swmatrix_row_25_w_clkbuf_0[24]/Q[15]
+ swmatrix_row_25_w_clkbuf_0[24]/Q[16] swmatrix_row_25_w_clkbuf_0[24]/Q[17] swmatrix_row_25_w_clkbuf_0[24]/Q[18]
+ swmatrix_row_25_w_clkbuf_0[24]/Q[19] swmatrix_row_25_w_clkbuf_0[24]/Q[20] swmatrix_row_25_w_clkbuf_0[24]/Q[21]
+ swmatrix_row_25_w_clkbuf_0[24]/Q[22] swmatrix_row_25_w_clkbuf_0[24]/Q[23] swmatrix_row_25_w_clkbuf_0[24]/Q[24]
+ swmatrix_row_25_w_clkbuf_0[23]/D_in PIN[106] swmatrix_row_25_w_clkbuf_0[24]/Q[1]
+ swmatrix_row_25_w_clkbuf_0[24]/Q[2] swmatrix_row_25_w_clkbuf_0[24]/D_in PHI_1_in
+ BUS[20] swmatrix_row_25_w_clkbuf_0[24]/ShiftReg_row_25_0/DFF_2phase_1$1_0[23]/gf180mcu_fd_sc_mcu9t5v0__latq_1$2_1/Q
+ BUS[23] enable_in BUS[22] BUS[25] PHI_2_in BUS[8] BUS[11] BUS[2] BUS[18] VSSd BUS[14]
+ BUS[5] swmatrix_row_25_w_clkbuf
Xswmatrix_row_25_w_clkbuf_0[25] VDDd BUS[24] BUS[21] BUS[19] BUS[17] BUS[16] BUS[15]
+ BUS[13] BUS[12] BUS[10] BUS[9] BUS[7] BUS[6] BUS[4] BUS[3] BUS[1] swmatrix_row_25_w_clkbuf_0[25]/Q[3]
+ swmatrix_row_25_w_clkbuf_0[25]/Q[4] swmatrix_row_25_w_clkbuf_0[25]/Q[5] swmatrix_row_25_w_clkbuf_0[25]/Q[6]
+ swmatrix_row_25_w_clkbuf_0[25]/Q[7] swmatrix_row_25_w_clkbuf_0[25]/Q[8] swmatrix_row_25_w_clkbuf_0[25]/Q[9]
+ swmatrix_row_25_w_clkbuf_0[25]/Q[10] swmatrix_row_25_w_clkbuf_0[25]/Q[11] swmatrix_row_25_w_clkbuf_0[25]/Q[12]
+ swmatrix_row_25_w_clkbuf_0[25]/Q[13] swmatrix_row_25_w_clkbuf_0[25]/Q[14] swmatrix_row_25_w_clkbuf_0[25]/Q[15]
+ swmatrix_row_25_w_clkbuf_0[25]/Q[16] swmatrix_row_25_w_clkbuf_0[25]/Q[17] swmatrix_row_25_w_clkbuf_0[25]/Q[18]
+ swmatrix_row_25_w_clkbuf_0[25]/Q[19] swmatrix_row_25_w_clkbuf_0[25]/Q[20] swmatrix_row_25_w_clkbuf_0[25]/Q[21]
+ swmatrix_row_25_w_clkbuf_0[25]/Q[22] swmatrix_row_25_w_clkbuf_0[25]/Q[23] swmatrix_row_25_w_clkbuf_0[25]/Q[24]
+ swmatrix_row_25_w_clkbuf_0[24]/D_in PIN[105] swmatrix_row_25_w_clkbuf_0[25]/Q[1]
+ swmatrix_row_25_w_clkbuf_0[25]/Q[2] swmatrix_row_25_w_clkbuf_0[25]/D_in PHI_1_in
+ BUS[20] swmatrix_row_25_w_clkbuf_0[25]/ShiftReg_row_25_0/DFF_2phase_1$1_0[23]/gf180mcu_fd_sc_mcu9t5v0__latq_1$2_1/Q
+ BUS[23] enable_in BUS[22] BUS[25] PHI_2_in BUS[8] BUS[11] BUS[2] BUS[18] VSSd BUS[14]
+ BUS[5] swmatrix_row_25_w_clkbuf
Xswmatrix_row_25_w_clkbuf_0[26] VDDd BUS[24] BUS[21] BUS[19] BUS[17] BUS[16] BUS[15]
+ BUS[13] BUS[12] BUS[10] BUS[9] BUS[7] BUS[6] BUS[4] BUS[3] BUS[1] swmatrix_row_25_w_clkbuf_0[26]/Q[3]
+ swmatrix_row_25_w_clkbuf_0[26]/Q[4] swmatrix_row_25_w_clkbuf_0[26]/Q[5] swmatrix_row_25_w_clkbuf_0[26]/Q[6]
+ swmatrix_row_25_w_clkbuf_0[26]/Q[7] swmatrix_row_25_w_clkbuf_0[26]/Q[8] swmatrix_row_25_w_clkbuf_0[26]/Q[9]
+ swmatrix_row_25_w_clkbuf_0[26]/Q[10] swmatrix_row_25_w_clkbuf_0[26]/Q[11] swmatrix_row_25_w_clkbuf_0[26]/Q[12]
+ swmatrix_row_25_w_clkbuf_0[26]/Q[13] swmatrix_row_25_w_clkbuf_0[26]/Q[14] swmatrix_row_25_w_clkbuf_0[26]/Q[15]
+ swmatrix_row_25_w_clkbuf_0[26]/Q[16] swmatrix_row_25_w_clkbuf_0[26]/Q[17] swmatrix_row_25_w_clkbuf_0[26]/Q[18]
+ swmatrix_row_25_w_clkbuf_0[26]/Q[19] swmatrix_row_25_w_clkbuf_0[26]/Q[20] swmatrix_row_25_w_clkbuf_0[26]/Q[21]
+ swmatrix_row_25_w_clkbuf_0[26]/Q[22] swmatrix_row_25_w_clkbuf_0[26]/Q[23] swmatrix_row_25_w_clkbuf_0[26]/Q[24]
+ swmatrix_row_25_w_clkbuf_0[25]/D_in PIN[104] swmatrix_row_25_w_clkbuf_0[26]/Q[1]
+ swmatrix_row_25_w_clkbuf_0[26]/Q[2] swmatrix_row_25_w_clkbuf_0[26]/D_in PHI_1_in
+ BUS[20] swmatrix_row_25_w_clkbuf_0[26]/ShiftReg_row_25_0/DFF_2phase_1$1_0[23]/gf180mcu_fd_sc_mcu9t5v0__latq_1$2_1/Q
+ BUS[23] enable_in BUS[22] BUS[25] PHI_2_in BUS[8] BUS[11] BUS[2] BUS[18] VSSd BUS[14]
+ BUS[5] swmatrix_row_25_w_clkbuf
Xswmatrix_row_25_w_clkbuf_0[27] VDDd BUS[24] BUS[21] BUS[19] BUS[17] BUS[16] BUS[15]
+ BUS[13] BUS[12] BUS[10] BUS[9] BUS[7] BUS[6] BUS[4] BUS[3] BUS[1] swmatrix_row_25_w_clkbuf_0[27]/Q[3]
+ swmatrix_row_25_w_clkbuf_0[27]/Q[4] swmatrix_row_25_w_clkbuf_0[27]/Q[5] swmatrix_row_25_w_clkbuf_0[27]/Q[6]
+ swmatrix_row_25_w_clkbuf_0[27]/Q[7] swmatrix_row_25_w_clkbuf_0[27]/Q[8] swmatrix_row_25_w_clkbuf_0[27]/Q[9]
+ swmatrix_row_25_w_clkbuf_0[27]/Q[10] swmatrix_row_25_w_clkbuf_0[27]/Q[11] swmatrix_row_25_w_clkbuf_0[27]/Q[12]
+ swmatrix_row_25_w_clkbuf_0[27]/Q[13] swmatrix_row_25_w_clkbuf_0[27]/Q[14] swmatrix_row_25_w_clkbuf_0[27]/Q[15]
+ swmatrix_row_25_w_clkbuf_0[27]/Q[16] swmatrix_row_25_w_clkbuf_0[27]/Q[17] swmatrix_row_25_w_clkbuf_0[27]/Q[18]
+ swmatrix_row_25_w_clkbuf_0[27]/Q[19] swmatrix_row_25_w_clkbuf_0[27]/Q[20] swmatrix_row_25_w_clkbuf_0[27]/Q[21]
+ swmatrix_row_25_w_clkbuf_0[27]/Q[22] swmatrix_row_25_w_clkbuf_0[27]/Q[23] swmatrix_row_25_w_clkbuf_0[27]/Q[24]
+ swmatrix_row_25_w_clkbuf_0[26]/D_in PIN[103] swmatrix_row_25_w_clkbuf_0[27]/Q[1]
+ swmatrix_row_25_w_clkbuf_0[27]/Q[2] swmatrix_row_25_w_clkbuf_0[27]/D_in PHI_1_in
+ BUS[20] swmatrix_row_25_w_clkbuf_0[27]/ShiftReg_row_25_0/DFF_2phase_1$1_0[23]/gf180mcu_fd_sc_mcu9t5v0__latq_1$2_1/Q
+ BUS[23] enable_in BUS[22] BUS[25] PHI_2_in BUS[8] BUS[11] BUS[2] BUS[18] VSSd BUS[14]
+ BUS[5] swmatrix_row_25_w_clkbuf
Xswmatrix_row_25_w_clkbuf_0[28] VDDd BUS[24] BUS[21] BUS[19] BUS[17] BUS[16] BUS[15]
+ BUS[13] BUS[12] BUS[10] BUS[9] BUS[7] BUS[6] BUS[4] BUS[3] BUS[1] swmatrix_row_25_w_clkbuf_0[28]/Q[3]
+ swmatrix_row_25_w_clkbuf_0[28]/Q[4] swmatrix_row_25_w_clkbuf_0[28]/Q[5] swmatrix_row_25_w_clkbuf_0[28]/Q[6]
+ swmatrix_row_25_w_clkbuf_0[28]/Q[7] swmatrix_row_25_w_clkbuf_0[28]/Q[8] swmatrix_row_25_w_clkbuf_0[28]/Q[9]
+ swmatrix_row_25_w_clkbuf_0[28]/Q[10] swmatrix_row_25_w_clkbuf_0[28]/Q[11] swmatrix_row_25_w_clkbuf_0[28]/Q[12]
+ swmatrix_row_25_w_clkbuf_0[28]/Q[13] swmatrix_row_25_w_clkbuf_0[28]/Q[14] swmatrix_row_25_w_clkbuf_0[28]/Q[15]
+ swmatrix_row_25_w_clkbuf_0[28]/Q[16] swmatrix_row_25_w_clkbuf_0[28]/Q[17] swmatrix_row_25_w_clkbuf_0[28]/Q[18]
+ swmatrix_row_25_w_clkbuf_0[28]/Q[19] swmatrix_row_25_w_clkbuf_0[28]/Q[20] swmatrix_row_25_w_clkbuf_0[28]/Q[21]
+ swmatrix_row_25_w_clkbuf_0[28]/Q[22] swmatrix_row_25_w_clkbuf_0[28]/Q[23] swmatrix_row_25_w_clkbuf_0[28]/Q[24]
+ swmatrix_row_25_w_clkbuf_0[27]/D_in PIN[102] swmatrix_row_25_w_clkbuf_0[28]/Q[1]
+ swmatrix_row_25_w_clkbuf_0[28]/Q[2] swmatrix_row_25_w_clkbuf_0[28]/D_in PHI_1_in
+ BUS[20] swmatrix_row_25_w_clkbuf_0[28]/ShiftReg_row_25_0/DFF_2phase_1$1_0[23]/gf180mcu_fd_sc_mcu9t5v0__latq_1$2_1/Q
+ BUS[23] enable_in BUS[22] BUS[25] PHI_2_in BUS[8] BUS[11] BUS[2] BUS[18] VSSd BUS[14]
+ BUS[5] swmatrix_row_25_w_clkbuf
Xswmatrix_row_25_w_clkbuf_0[29] VDDd BUS[24] BUS[21] BUS[19] BUS[17] BUS[16] BUS[15]
+ BUS[13] BUS[12] BUS[10] BUS[9] BUS[7] BUS[6] BUS[4] BUS[3] BUS[1] swmatrix_row_25_w_clkbuf_0[29]/Q[3]
+ swmatrix_row_25_w_clkbuf_0[29]/Q[4] swmatrix_row_25_w_clkbuf_0[29]/Q[5] swmatrix_row_25_w_clkbuf_0[29]/Q[6]
+ swmatrix_row_25_w_clkbuf_0[29]/Q[7] swmatrix_row_25_w_clkbuf_0[29]/Q[8] swmatrix_row_25_w_clkbuf_0[29]/Q[9]
+ swmatrix_row_25_w_clkbuf_0[29]/Q[10] swmatrix_row_25_w_clkbuf_0[29]/Q[11] swmatrix_row_25_w_clkbuf_0[29]/Q[12]
+ swmatrix_row_25_w_clkbuf_0[29]/Q[13] swmatrix_row_25_w_clkbuf_0[29]/Q[14] swmatrix_row_25_w_clkbuf_0[29]/Q[15]
+ swmatrix_row_25_w_clkbuf_0[29]/Q[16] swmatrix_row_25_w_clkbuf_0[29]/Q[17] swmatrix_row_25_w_clkbuf_0[29]/Q[18]
+ swmatrix_row_25_w_clkbuf_0[29]/Q[19] swmatrix_row_25_w_clkbuf_0[29]/Q[20] swmatrix_row_25_w_clkbuf_0[29]/Q[21]
+ swmatrix_row_25_w_clkbuf_0[29]/Q[22] swmatrix_row_25_w_clkbuf_0[29]/Q[23] swmatrix_row_25_w_clkbuf_0[29]/Q[24]
+ swmatrix_row_25_w_clkbuf_0[28]/D_in PIN[101] swmatrix_row_25_w_clkbuf_0[29]/Q[1]
+ swmatrix_row_25_w_clkbuf_0[29]/Q[2] swmatrix_row_25_w_clkbuf_0[29]/D_in PHI_1_in
+ BUS[20] swmatrix_row_25_w_clkbuf_0[29]/ShiftReg_row_25_0/DFF_2phase_1$1_0[23]/gf180mcu_fd_sc_mcu9t5v0__latq_1$2_1/Q
+ BUS[23] enable_in BUS[22] BUS[25] PHI_2_in BUS[8] BUS[11] BUS[2] BUS[18] VSSd BUS[14]
+ BUS[5] swmatrix_row_25_w_clkbuf
Xswmatrix_row_25_w_clkbuf_0[30] VDDd BUS[24] BUS[21] BUS[19] BUS[17] BUS[16] BUS[15]
+ BUS[13] BUS[12] BUS[10] BUS[9] BUS[7] BUS[6] BUS[4] BUS[3] BUS[1] swmatrix_row_25_w_clkbuf_0[30]/Q[3]
+ swmatrix_row_25_w_clkbuf_0[30]/Q[4] swmatrix_row_25_w_clkbuf_0[30]/Q[5] swmatrix_row_25_w_clkbuf_0[30]/Q[6]
+ swmatrix_row_25_w_clkbuf_0[30]/Q[7] swmatrix_row_25_w_clkbuf_0[30]/Q[8] swmatrix_row_25_w_clkbuf_0[30]/Q[9]
+ swmatrix_row_25_w_clkbuf_0[30]/Q[10] swmatrix_row_25_w_clkbuf_0[30]/Q[11] swmatrix_row_25_w_clkbuf_0[30]/Q[12]
+ swmatrix_row_25_w_clkbuf_0[30]/Q[13] swmatrix_row_25_w_clkbuf_0[30]/Q[14] swmatrix_row_25_w_clkbuf_0[30]/Q[15]
+ swmatrix_row_25_w_clkbuf_0[30]/Q[16] swmatrix_row_25_w_clkbuf_0[30]/Q[17] swmatrix_row_25_w_clkbuf_0[30]/Q[18]
+ swmatrix_row_25_w_clkbuf_0[30]/Q[19] swmatrix_row_25_w_clkbuf_0[30]/Q[20] swmatrix_row_25_w_clkbuf_0[30]/Q[21]
+ swmatrix_row_25_w_clkbuf_0[30]/Q[22] swmatrix_row_25_w_clkbuf_0[30]/Q[23] swmatrix_row_25_w_clkbuf_0[30]/Q[24]
+ swmatrix_row_25_w_clkbuf_0[29]/D_in PIN[100] swmatrix_row_25_w_clkbuf_0[30]/Q[1]
+ swmatrix_row_25_w_clkbuf_0[30]/Q[2] swmatrix_row_25_w_clkbuf_0[30]/D_in PHI_1_in
+ BUS[20] swmatrix_row_25_w_clkbuf_0[30]/ShiftReg_row_25_0/DFF_2phase_1$1_0[23]/gf180mcu_fd_sc_mcu9t5v0__latq_1$2_1/Q
+ BUS[23] enable_in BUS[22] BUS[25] PHI_2_in BUS[8] BUS[11] BUS[2] BUS[18] VSSd BUS[14]
+ BUS[5] swmatrix_row_25_w_clkbuf
Xswmatrix_row_25_w_clkbuf_0[31] VDDd BUS[24] BUS[21] BUS[19] BUS[17] BUS[16] BUS[15]
+ BUS[13] BUS[12] BUS[10] BUS[9] BUS[7] BUS[6] BUS[4] BUS[3] BUS[1] swmatrix_row_25_w_clkbuf_0[31]/Q[3]
+ swmatrix_row_25_w_clkbuf_0[31]/Q[4] swmatrix_row_25_w_clkbuf_0[31]/Q[5] swmatrix_row_25_w_clkbuf_0[31]/Q[6]
+ swmatrix_row_25_w_clkbuf_0[31]/Q[7] swmatrix_row_25_w_clkbuf_0[31]/Q[8] swmatrix_row_25_w_clkbuf_0[31]/Q[9]
+ swmatrix_row_25_w_clkbuf_0[31]/Q[10] swmatrix_row_25_w_clkbuf_0[31]/Q[11] swmatrix_row_25_w_clkbuf_0[31]/Q[12]
+ swmatrix_row_25_w_clkbuf_0[31]/Q[13] swmatrix_row_25_w_clkbuf_0[31]/Q[14] swmatrix_row_25_w_clkbuf_0[31]/Q[15]
+ swmatrix_row_25_w_clkbuf_0[31]/Q[16] swmatrix_row_25_w_clkbuf_0[31]/Q[17] swmatrix_row_25_w_clkbuf_0[31]/Q[18]
+ swmatrix_row_25_w_clkbuf_0[31]/Q[19] swmatrix_row_25_w_clkbuf_0[31]/Q[20] swmatrix_row_25_w_clkbuf_0[31]/Q[21]
+ swmatrix_row_25_w_clkbuf_0[31]/Q[22] swmatrix_row_25_w_clkbuf_0[31]/Q[23] swmatrix_row_25_w_clkbuf_0[31]/Q[24]
+ swmatrix_row_25_w_clkbuf_0[30]/D_in PIN[99] swmatrix_row_25_w_clkbuf_0[31]/Q[1]
+ swmatrix_row_25_w_clkbuf_0[31]/Q[2] swmatrix_row_25_w_clkbuf_0[31]/D_in PHI_1_in
+ BUS[20] swmatrix_row_25_w_clkbuf_0[31]/ShiftReg_row_25_0/DFF_2phase_1$1_0[23]/gf180mcu_fd_sc_mcu9t5v0__latq_1$2_1/Q
+ BUS[23] enable_in BUS[22] BUS[25] PHI_2_in BUS[8] BUS[11] BUS[2] BUS[18] VSSd BUS[14]
+ BUS[5] swmatrix_row_25_w_clkbuf
Xswmatrix_row_25_w_clkbuf_0[32] VDDd BUS[24] BUS[21] BUS[19] BUS[17] BUS[16] BUS[15]
+ BUS[13] BUS[12] BUS[10] BUS[9] BUS[7] BUS[6] BUS[4] BUS[3] BUS[1] swmatrix_row_25_w_clkbuf_0[32]/Q[3]
+ swmatrix_row_25_w_clkbuf_0[32]/Q[4] swmatrix_row_25_w_clkbuf_0[32]/Q[5] swmatrix_row_25_w_clkbuf_0[32]/Q[6]
+ swmatrix_row_25_w_clkbuf_0[32]/Q[7] swmatrix_row_25_w_clkbuf_0[32]/Q[8] swmatrix_row_25_w_clkbuf_0[32]/Q[9]
+ swmatrix_row_25_w_clkbuf_0[32]/Q[10] swmatrix_row_25_w_clkbuf_0[32]/Q[11] swmatrix_row_25_w_clkbuf_0[32]/Q[12]
+ swmatrix_row_25_w_clkbuf_0[32]/Q[13] swmatrix_row_25_w_clkbuf_0[32]/Q[14] swmatrix_row_25_w_clkbuf_0[32]/Q[15]
+ swmatrix_row_25_w_clkbuf_0[32]/Q[16] swmatrix_row_25_w_clkbuf_0[32]/Q[17] swmatrix_row_25_w_clkbuf_0[32]/Q[18]
+ swmatrix_row_25_w_clkbuf_0[32]/Q[19] swmatrix_row_25_w_clkbuf_0[32]/Q[20] swmatrix_row_25_w_clkbuf_0[32]/Q[21]
+ swmatrix_row_25_w_clkbuf_0[32]/Q[22] swmatrix_row_25_w_clkbuf_0[32]/Q[23] swmatrix_row_25_w_clkbuf_0[32]/Q[24]
+ swmatrix_row_25_w_clkbuf_0[31]/D_in PIN[98] swmatrix_row_25_w_clkbuf_0[32]/Q[1]
+ swmatrix_row_25_w_clkbuf_0[32]/Q[2] swmatrix_row_25_w_clkbuf_0[32]/D_in PHI_1_in
+ BUS[20] swmatrix_row_25_w_clkbuf_0[32]/ShiftReg_row_25_0/DFF_2phase_1$1_0[23]/gf180mcu_fd_sc_mcu9t5v0__latq_1$2_1/Q
+ BUS[23] enable_in BUS[22] BUS[25] PHI_2_in BUS[8] BUS[11] BUS[2] BUS[18] VSSd BUS[14]
+ BUS[5] swmatrix_row_25_w_clkbuf
Xswmatrix_row_25_w_clkbuf_0[33] VDDd BUS[24] BUS[21] BUS[19] BUS[17] BUS[16] BUS[15]
+ BUS[13] BUS[12] BUS[10] BUS[9] BUS[7] BUS[6] BUS[4] BUS[3] BUS[1] swmatrix_row_25_w_clkbuf_0[33]/Q[3]
+ swmatrix_row_25_w_clkbuf_0[33]/Q[4] swmatrix_row_25_w_clkbuf_0[33]/Q[5] swmatrix_row_25_w_clkbuf_0[33]/Q[6]
+ swmatrix_row_25_w_clkbuf_0[33]/Q[7] swmatrix_row_25_w_clkbuf_0[33]/Q[8] swmatrix_row_25_w_clkbuf_0[33]/Q[9]
+ swmatrix_row_25_w_clkbuf_0[33]/Q[10] swmatrix_row_25_w_clkbuf_0[33]/Q[11] swmatrix_row_25_w_clkbuf_0[33]/Q[12]
+ swmatrix_row_25_w_clkbuf_0[33]/Q[13] swmatrix_row_25_w_clkbuf_0[33]/Q[14] swmatrix_row_25_w_clkbuf_0[33]/Q[15]
+ swmatrix_row_25_w_clkbuf_0[33]/Q[16] swmatrix_row_25_w_clkbuf_0[33]/Q[17] swmatrix_row_25_w_clkbuf_0[33]/Q[18]
+ swmatrix_row_25_w_clkbuf_0[33]/Q[19] swmatrix_row_25_w_clkbuf_0[33]/Q[20] swmatrix_row_25_w_clkbuf_0[33]/Q[21]
+ swmatrix_row_25_w_clkbuf_0[33]/Q[22] swmatrix_row_25_w_clkbuf_0[33]/Q[23] swmatrix_row_25_w_clkbuf_0[33]/Q[24]
+ swmatrix_row_25_w_clkbuf_0[32]/D_in PIN[97] swmatrix_row_25_w_clkbuf_0[33]/Q[1]
+ swmatrix_row_25_w_clkbuf_0[33]/Q[2] swmatrix_row_25_w_clkbuf_0[33]/D_in PHI_1_in
+ BUS[20] swmatrix_row_25_w_clkbuf_0[33]/ShiftReg_row_25_0/DFF_2phase_1$1_0[23]/gf180mcu_fd_sc_mcu9t5v0__latq_1$2_1/Q
+ BUS[23] enable_in BUS[22] BUS[25] PHI_2_in BUS[8] BUS[11] BUS[2] BUS[18] VSSd BUS[14]
+ BUS[5] swmatrix_row_25_w_clkbuf
Xswmatrix_row_25_w_clkbuf_0[34] VDDd BUS[24] BUS[21] BUS[19] BUS[17] BUS[16] BUS[15]
+ BUS[13] BUS[12] BUS[10] BUS[9] BUS[7] BUS[6] BUS[4] BUS[3] BUS[1] swmatrix_row_25_w_clkbuf_0[34]/Q[3]
+ swmatrix_row_25_w_clkbuf_0[34]/Q[4] swmatrix_row_25_w_clkbuf_0[34]/Q[5] swmatrix_row_25_w_clkbuf_0[34]/Q[6]
+ swmatrix_row_25_w_clkbuf_0[34]/Q[7] swmatrix_row_25_w_clkbuf_0[34]/Q[8] swmatrix_row_25_w_clkbuf_0[34]/Q[9]
+ swmatrix_row_25_w_clkbuf_0[34]/Q[10] swmatrix_row_25_w_clkbuf_0[34]/Q[11] swmatrix_row_25_w_clkbuf_0[34]/Q[12]
+ swmatrix_row_25_w_clkbuf_0[34]/Q[13] swmatrix_row_25_w_clkbuf_0[34]/Q[14] swmatrix_row_25_w_clkbuf_0[34]/Q[15]
+ swmatrix_row_25_w_clkbuf_0[34]/Q[16] swmatrix_row_25_w_clkbuf_0[34]/Q[17] swmatrix_row_25_w_clkbuf_0[34]/Q[18]
+ swmatrix_row_25_w_clkbuf_0[34]/Q[19] swmatrix_row_25_w_clkbuf_0[34]/Q[20] swmatrix_row_25_w_clkbuf_0[34]/Q[21]
+ swmatrix_row_25_w_clkbuf_0[34]/Q[22] swmatrix_row_25_w_clkbuf_0[34]/Q[23] swmatrix_row_25_w_clkbuf_0[34]/Q[24]
+ swmatrix_row_25_w_clkbuf_0[33]/D_in PIN[96] swmatrix_row_25_w_clkbuf_0[34]/Q[1]
+ swmatrix_row_25_w_clkbuf_0[34]/Q[2] swmatrix_row_25_w_clkbuf_0[34]/D_in PHI_1_in
+ BUS[20] swmatrix_row_25_w_clkbuf_0[34]/ShiftReg_row_25_0/DFF_2phase_1$1_0[23]/gf180mcu_fd_sc_mcu9t5v0__latq_1$2_1/Q
+ BUS[23] enable_in BUS[22] BUS[25] PHI_2_in BUS[8] BUS[11] BUS[2] BUS[18] VSSd BUS[14]
+ BUS[5] swmatrix_row_25_w_clkbuf
Xswmatrix_row_25_w_clkbuf_0[35] VDDd BUS[24] BUS[21] BUS[19] BUS[17] BUS[16] BUS[15]
+ BUS[13] BUS[12] BUS[10] BUS[9] BUS[7] BUS[6] BUS[4] BUS[3] BUS[1] swmatrix_row_25_w_clkbuf_0[35]/Q[3]
+ swmatrix_row_25_w_clkbuf_0[35]/Q[4] swmatrix_row_25_w_clkbuf_0[35]/Q[5] swmatrix_row_25_w_clkbuf_0[35]/Q[6]
+ swmatrix_row_25_w_clkbuf_0[35]/Q[7] swmatrix_row_25_w_clkbuf_0[35]/Q[8] swmatrix_row_25_w_clkbuf_0[35]/Q[9]
+ swmatrix_row_25_w_clkbuf_0[35]/Q[10] swmatrix_row_25_w_clkbuf_0[35]/Q[11] swmatrix_row_25_w_clkbuf_0[35]/Q[12]
+ swmatrix_row_25_w_clkbuf_0[35]/Q[13] swmatrix_row_25_w_clkbuf_0[35]/Q[14] swmatrix_row_25_w_clkbuf_0[35]/Q[15]
+ swmatrix_row_25_w_clkbuf_0[35]/Q[16] swmatrix_row_25_w_clkbuf_0[35]/Q[17] swmatrix_row_25_w_clkbuf_0[35]/Q[18]
+ swmatrix_row_25_w_clkbuf_0[35]/Q[19] swmatrix_row_25_w_clkbuf_0[35]/Q[20] swmatrix_row_25_w_clkbuf_0[35]/Q[21]
+ swmatrix_row_25_w_clkbuf_0[35]/Q[22] swmatrix_row_25_w_clkbuf_0[35]/Q[23] swmatrix_row_25_w_clkbuf_0[35]/Q[24]
+ swmatrix_row_25_w_clkbuf_0[34]/D_in PIN[95] swmatrix_row_25_w_clkbuf_0[35]/Q[1]
+ swmatrix_row_25_w_clkbuf_0[35]/Q[2] swmatrix_row_25_w_clkbuf_0[35]/D_in PHI_1_in
+ BUS[20] swmatrix_row_25_w_clkbuf_0[35]/ShiftReg_row_25_0/DFF_2phase_1$1_0[23]/gf180mcu_fd_sc_mcu9t5v0__latq_1$2_1/Q
+ BUS[23] enable_in BUS[22] BUS[25] PHI_2_in BUS[8] BUS[11] BUS[2] BUS[18] VSSd BUS[14]
+ BUS[5] swmatrix_row_25_w_clkbuf
Xswmatrix_row_25_w_clkbuf_0[36] VDDd BUS[24] BUS[21] BUS[19] BUS[17] BUS[16] BUS[15]
+ BUS[13] BUS[12] BUS[10] BUS[9] BUS[7] BUS[6] BUS[4] BUS[3] BUS[1] swmatrix_row_25_w_clkbuf_0[36]/Q[3]
+ swmatrix_row_25_w_clkbuf_0[36]/Q[4] swmatrix_row_25_w_clkbuf_0[36]/Q[5] swmatrix_row_25_w_clkbuf_0[36]/Q[6]
+ swmatrix_row_25_w_clkbuf_0[36]/Q[7] swmatrix_row_25_w_clkbuf_0[36]/Q[8] swmatrix_row_25_w_clkbuf_0[36]/Q[9]
+ swmatrix_row_25_w_clkbuf_0[36]/Q[10] swmatrix_row_25_w_clkbuf_0[36]/Q[11] swmatrix_row_25_w_clkbuf_0[36]/Q[12]
+ swmatrix_row_25_w_clkbuf_0[36]/Q[13] swmatrix_row_25_w_clkbuf_0[36]/Q[14] swmatrix_row_25_w_clkbuf_0[36]/Q[15]
+ swmatrix_row_25_w_clkbuf_0[36]/Q[16] swmatrix_row_25_w_clkbuf_0[36]/Q[17] swmatrix_row_25_w_clkbuf_0[36]/Q[18]
+ swmatrix_row_25_w_clkbuf_0[36]/Q[19] swmatrix_row_25_w_clkbuf_0[36]/Q[20] swmatrix_row_25_w_clkbuf_0[36]/Q[21]
+ swmatrix_row_25_w_clkbuf_0[36]/Q[22] swmatrix_row_25_w_clkbuf_0[36]/Q[23] swmatrix_row_25_w_clkbuf_0[36]/Q[24]
+ swmatrix_row_25_w_clkbuf_0[35]/D_in PIN[94] swmatrix_row_25_w_clkbuf_0[36]/Q[1]
+ swmatrix_row_25_w_clkbuf_0[36]/Q[2] swmatrix_row_25_w_clkbuf_0[36]/D_in PHI_1_in
+ BUS[20] swmatrix_row_25_w_clkbuf_0[36]/ShiftReg_row_25_0/DFF_2phase_1$1_0[23]/gf180mcu_fd_sc_mcu9t5v0__latq_1$2_1/Q
+ BUS[23] enable_in BUS[22] BUS[25] PHI_2_in BUS[8] BUS[11] BUS[2] BUS[18] VSSd BUS[14]
+ BUS[5] swmatrix_row_25_w_clkbuf
Xswmatrix_row_25_w_clkbuf_0[37] VDDd BUS[24] BUS[21] BUS[19] BUS[17] BUS[16] BUS[15]
+ BUS[13] BUS[12] BUS[10] BUS[9] BUS[7] BUS[6] BUS[4] BUS[3] BUS[1] swmatrix_row_25_w_clkbuf_0[37]/Q[3]
+ swmatrix_row_25_w_clkbuf_0[37]/Q[4] swmatrix_row_25_w_clkbuf_0[37]/Q[5] swmatrix_row_25_w_clkbuf_0[37]/Q[6]
+ swmatrix_row_25_w_clkbuf_0[37]/Q[7] swmatrix_row_25_w_clkbuf_0[37]/Q[8] swmatrix_row_25_w_clkbuf_0[37]/Q[9]
+ swmatrix_row_25_w_clkbuf_0[37]/Q[10] swmatrix_row_25_w_clkbuf_0[37]/Q[11] swmatrix_row_25_w_clkbuf_0[37]/Q[12]
+ swmatrix_row_25_w_clkbuf_0[37]/Q[13] swmatrix_row_25_w_clkbuf_0[37]/Q[14] swmatrix_row_25_w_clkbuf_0[37]/Q[15]
+ swmatrix_row_25_w_clkbuf_0[37]/Q[16] swmatrix_row_25_w_clkbuf_0[37]/Q[17] swmatrix_row_25_w_clkbuf_0[37]/Q[18]
+ swmatrix_row_25_w_clkbuf_0[37]/Q[19] swmatrix_row_25_w_clkbuf_0[37]/Q[20] swmatrix_row_25_w_clkbuf_0[37]/Q[21]
+ swmatrix_row_25_w_clkbuf_0[37]/Q[22] swmatrix_row_25_w_clkbuf_0[37]/Q[23] swmatrix_row_25_w_clkbuf_0[37]/Q[24]
+ swmatrix_row_25_w_clkbuf_0[36]/D_in PIN[93] swmatrix_row_25_w_clkbuf_0[37]/Q[1]
+ swmatrix_row_25_w_clkbuf_0[37]/Q[2] swmatrix_row_25_w_clkbuf_0[37]/D_in PHI_1_in
+ BUS[20] swmatrix_row_25_w_clkbuf_0[37]/ShiftReg_row_25_0/DFF_2phase_1$1_0[23]/gf180mcu_fd_sc_mcu9t5v0__latq_1$2_1/Q
+ BUS[23] enable_in BUS[22] BUS[25] PHI_2_in BUS[8] BUS[11] BUS[2] BUS[18] VSSd BUS[14]
+ BUS[5] swmatrix_row_25_w_clkbuf
Xswmatrix_row_25_w_clkbuf_0[38] VDDd BUS[24] BUS[21] BUS[19] BUS[17] BUS[16] BUS[15]
+ BUS[13] BUS[12] BUS[10] BUS[9] BUS[7] BUS[6] BUS[4] BUS[3] BUS[1] swmatrix_row_25_w_clkbuf_0[38]/Q[3]
+ swmatrix_row_25_w_clkbuf_0[38]/Q[4] swmatrix_row_25_w_clkbuf_0[38]/Q[5] swmatrix_row_25_w_clkbuf_0[38]/Q[6]
+ swmatrix_row_25_w_clkbuf_0[38]/Q[7] swmatrix_row_25_w_clkbuf_0[38]/Q[8] swmatrix_row_25_w_clkbuf_0[38]/Q[9]
+ swmatrix_row_25_w_clkbuf_0[38]/Q[10] swmatrix_row_25_w_clkbuf_0[38]/Q[11] swmatrix_row_25_w_clkbuf_0[38]/Q[12]
+ swmatrix_row_25_w_clkbuf_0[38]/Q[13] swmatrix_row_25_w_clkbuf_0[38]/Q[14] swmatrix_row_25_w_clkbuf_0[38]/Q[15]
+ swmatrix_row_25_w_clkbuf_0[38]/Q[16] swmatrix_row_25_w_clkbuf_0[38]/Q[17] swmatrix_row_25_w_clkbuf_0[38]/Q[18]
+ swmatrix_row_25_w_clkbuf_0[38]/Q[19] swmatrix_row_25_w_clkbuf_0[38]/Q[20] swmatrix_row_25_w_clkbuf_0[38]/Q[21]
+ swmatrix_row_25_w_clkbuf_0[38]/Q[22] swmatrix_row_25_w_clkbuf_0[38]/Q[23] swmatrix_row_25_w_clkbuf_0[38]/Q[24]
+ swmatrix_row_25_w_clkbuf_0[37]/D_in PIN[92] swmatrix_row_25_w_clkbuf_0[38]/Q[1]
+ swmatrix_row_25_w_clkbuf_0[38]/Q[2] swmatrix_row_25_w_clkbuf_0[38]/D_in PHI_1_in
+ BUS[20] swmatrix_row_25_w_clkbuf_0[38]/ShiftReg_row_25_0/DFF_2phase_1$1_0[23]/gf180mcu_fd_sc_mcu9t5v0__latq_1$2_1/Q
+ BUS[23] enable_in BUS[22] BUS[25] PHI_2_in BUS[8] BUS[11] BUS[2] BUS[18] VSSd BUS[14]
+ BUS[5] swmatrix_row_25_w_clkbuf
Xswmatrix_row_25_w_clkbuf_0[39] VDDd BUS[24] BUS[21] BUS[19] BUS[17] BUS[16] BUS[15]
+ BUS[13] BUS[12] BUS[10] BUS[9] BUS[7] BUS[6] BUS[4] BUS[3] BUS[1] swmatrix_row_25_w_clkbuf_0[39]/Q[3]
+ swmatrix_row_25_w_clkbuf_0[39]/Q[4] swmatrix_row_25_w_clkbuf_0[39]/Q[5] swmatrix_row_25_w_clkbuf_0[39]/Q[6]
+ swmatrix_row_25_w_clkbuf_0[39]/Q[7] swmatrix_row_25_w_clkbuf_0[39]/Q[8] swmatrix_row_25_w_clkbuf_0[39]/Q[9]
+ swmatrix_row_25_w_clkbuf_0[39]/Q[10] swmatrix_row_25_w_clkbuf_0[39]/Q[11] swmatrix_row_25_w_clkbuf_0[39]/Q[12]
+ swmatrix_row_25_w_clkbuf_0[39]/Q[13] swmatrix_row_25_w_clkbuf_0[39]/Q[14] swmatrix_row_25_w_clkbuf_0[39]/Q[15]
+ swmatrix_row_25_w_clkbuf_0[39]/Q[16] swmatrix_row_25_w_clkbuf_0[39]/Q[17] swmatrix_row_25_w_clkbuf_0[39]/Q[18]
+ swmatrix_row_25_w_clkbuf_0[39]/Q[19] swmatrix_row_25_w_clkbuf_0[39]/Q[20] swmatrix_row_25_w_clkbuf_0[39]/Q[21]
+ swmatrix_row_25_w_clkbuf_0[39]/Q[22] swmatrix_row_25_w_clkbuf_0[39]/Q[23] swmatrix_row_25_w_clkbuf_0[39]/Q[24]
+ swmatrix_row_25_w_clkbuf_0[38]/D_in PIN[91] swmatrix_row_25_w_clkbuf_0[39]/Q[1]
+ swmatrix_row_25_w_clkbuf_0[39]/Q[2] swmatrix_row_25_w_clkbuf_0[39]/D_in PHI_1_in
+ BUS[20] swmatrix_row_25_w_clkbuf_0[39]/ShiftReg_row_25_0/DFF_2phase_1$1_0[23]/gf180mcu_fd_sc_mcu9t5v0__latq_1$2_1/Q
+ BUS[23] enable_in BUS[22] BUS[25] PHI_2_in BUS[8] BUS[11] BUS[2] BUS[18] VSSd BUS[14]
+ BUS[5] swmatrix_row_25_w_clkbuf
Xswmatrix_row_25_w_clkbuf_0[40] VDDd BUS[24] BUS[21] BUS[19] BUS[17] BUS[16] BUS[15]
+ BUS[13] BUS[12] BUS[10] BUS[9] BUS[7] BUS[6] BUS[4] BUS[3] BUS[1] swmatrix_row_25_w_clkbuf_0[40]/Q[3]
+ swmatrix_row_25_w_clkbuf_0[40]/Q[4] swmatrix_row_25_w_clkbuf_0[40]/Q[5] swmatrix_row_25_w_clkbuf_0[40]/Q[6]
+ swmatrix_row_25_w_clkbuf_0[40]/Q[7] swmatrix_row_25_w_clkbuf_0[40]/Q[8] swmatrix_row_25_w_clkbuf_0[40]/Q[9]
+ swmatrix_row_25_w_clkbuf_0[40]/Q[10] swmatrix_row_25_w_clkbuf_0[40]/Q[11] swmatrix_row_25_w_clkbuf_0[40]/Q[12]
+ swmatrix_row_25_w_clkbuf_0[40]/Q[13] swmatrix_row_25_w_clkbuf_0[40]/Q[14] swmatrix_row_25_w_clkbuf_0[40]/Q[15]
+ swmatrix_row_25_w_clkbuf_0[40]/Q[16] swmatrix_row_25_w_clkbuf_0[40]/Q[17] swmatrix_row_25_w_clkbuf_0[40]/Q[18]
+ swmatrix_row_25_w_clkbuf_0[40]/Q[19] swmatrix_row_25_w_clkbuf_0[40]/Q[20] swmatrix_row_25_w_clkbuf_0[40]/Q[21]
+ swmatrix_row_25_w_clkbuf_0[40]/Q[22] swmatrix_row_25_w_clkbuf_0[40]/Q[23] swmatrix_row_25_w_clkbuf_0[40]/Q[24]
+ swmatrix_row_25_w_clkbuf_0[39]/D_in PIN[90] swmatrix_row_25_w_clkbuf_0[40]/Q[1]
+ swmatrix_row_25_w_clkbuf_0[40]/Q[2] swmatrix_row_25_w_clkbuf_0[40]/D_in PHI_1_in
+ BUS[20] swmatrix_row_25_w_clkbuf_0[40]/ShiftReg_row_25_0/DFF_2phase_1$1_0[23]/gf180mcu_fd_sc_mcu9t5v0__latq_1$2_1/Q
+ BUS[23] enable_in BUS[22] BUS[25] PHI_2_in BUS[8] BUS[11] BUS[2] BUS[18] VSSd BUS[14]
+ BUS[5] swmatrix_row_25_w_clkbuf
Xswmatrix_row_25_w_clkbuf_0[41] VDDd BUS[24] BUS[21] BUS[19] BUS[17] BUS[16] BUS[15]
+ BUS[13] BUS[12] BUS[10] BUS[9] BUS[7] BUS[6] BUS[4] BUS[3] BUS[1] swmatrix_row_25_w_clkbuf_0[41]/Q[3]
+ swmatrix_row_25_w_clkbuf_0[41]/Q[4] swmatrix_row_25_w_clkbuf_0[41]/Q[5] swmatrix_row_25_w_clkbuf_0[41]/Q[6]
+ swmatrix_row_25_w_clkbuf_0[41]/Q[7] swmatrix_row_25_w_clkbuf_0[41]/Q[8] swmatrix_row_25_w_clkbuf_0[41]/Q[9]
+ swmatrix_row_25_w_clkbuf_0[41]/Q[10] swmatrix_row_25_w_clkbuf_0[41]/Q[11] swmatrix_row_25_w_clkbuf_0[41]/Q[12]
+ swmatrix_row_25_w_clkbuf_0[41]/Q[13] swmatrix_row_25_w_clkbuf_0[41]/Q[14] swmatrix_row_25_w_clkbuf_0[41]/Q[15]
+ swmatrix_row_25_w_clkbuf_0[41]/Q[16] swmatrix_row_25_w_clkbuf_0[41]/Q[17] swmatrix_row_25_w_clkbuf_0[41]/Q[18]
+ swmatrix_row_25_w_clkbuf_0[41]/Q[19] swmatrix_row_25_w_clkbuf_0[41]/Q[20] swmatrix_row_25_w_clkbuf_0[41]/Q[21]
+ swmatrix_row_25_w_clkbuf_0[41]/Q[22] swmatrix_row_25_w_clkbuf_0[41]/Q[23] swmatrix_row_25_w_clkbuf_0[41]/Q[24]
+ swmatrix_row_25_w_clkbuf_0[40]/D_in PIN[89] swmatrix_row_25_w_clkbuf_0[41]/Q[1]
+ swmatrix_row_25_w_clkbuf_0[41]/Q[2] swmatrix_row_25_w_clkbuf_0[41]/D_in PHI_1_in
+ BUS[20] swmatrix_row_25_w_clkbuf_0[41]/ShiftReg_row_25_0/DFF_2phase_1$1_0[23]/gf180mcu_fd_sc_mcu9t5v0__latq_1$2_1/Q
+ BUS[23] enable_in BUS[22] BUS[25] PHI_2_in BUS[8] BUS[11] BUS[2] BUS[18] VSSd BUS[14]
+ BUS[5] swmatrix_row_25_w_clkbuf
Xswmatrix_row_25_w_clkbuf_0[42] VDDd BUS[24] BUS[21] BUS[19] BUS[17] BUS[16] BUS[15]
+ BUS[13] BUS[12] BUS[10] BUS[9] BUS[7] BUS[6] BUS[4] BUS[3] BUS[1] swmatrix_row_25_w_clkbuf_0[42]/Q[3]
+ swmatrix_row_25_w_clkbuf_0[42]/Q[4] swmatrix_row_25_w_clkbuf_0[42]/Q[5] swmatrix_row_25_w_clkbuf_0[42]/Q[6]
+ swmatrix_row_25_w_clkbuf_0[42]/Q[7] swmatrix_row_25_w_clkbuf_0[42]/Q[8] swmatrix_row_25_w_clkbuf_0[42]/Q[9]
+ swmatrix_row_25_w_clkbuf_0[42]/Q[10] swmatrix_row_25_w_clkbuf_0[42]/Q[11] swmatrix_row_25_w_clkbuf_0[42]/Q[12]
+ swmatrix_row_25_w_clkbuf_0[42]/Q[13] swmatrix_row_25_w_clkbuf_0[42]/Q[14] swmatrix_row_25_w_clkbuf_0[42]/Q[15]
+ swmatrix_row_25_w_clkbuf_0[42]/Q[16] swmatrix_row_25_w_clkbuf_0[42]/Q[17] swmatrix_row_25_w_clkbuf_0[42]/Q[18]
+ swmatrix_row_25_w_clkbuf_0[42]/Q[19] swmatrix_row_25_w_clkbuf_0[42]/Q[20] swmatrix_row_25_w_clkbuf_0[42]/Q[21]
+ swmatrix_row_25_w_clkbuf_0[42]/Q[22] swmatrix_row_25_w_clkbuf_0[42]/Q[23] swmatrix_row_25_w_clkbuf_0[42]/Q[24]
+ swmatrix_row_25_w_clkbuf_0[41]/D_in PIN[88] swmatrix_row_25_w_clkbuf_0[42]/Q[1]
+ swmatrix_row_25_w_clkbuf_0[42]/Q[2] swmatrix_row_25_w_clkbuf_0[42]/D_in PHI_1_in
+ BUS[20] swmatrix_row_25_w_clkbuf_0[42]/ShiftReg_row_25_0/DFF_2phase_1$1_0[23]/gf180mcu_fd_sc_mcu9t5v0__latq_1$2_1/Q
+ BUS[23] enable_in BUS[22] BUS[25] PHI_2_in BUS[8] BUS[11] BUS[2] BUS[18] VSSd BUS[14]
+ BUS[5] swmatrix_row_25_w_clkbuf
Xswmatrix_row_25_w_clkbuf_0[43] VDDd BUS[24] BUS[21] BUS[19] BUS[17] BUS[16] BUS[15]
+ BUS[13] BUS[12] BUS[10] BUS[9] BUS[7] BUS[6] BUS[4] BUS[3] BUS[1] swmatrix_row_25_w_clkbuf_0[43]/Q[3]
+ swmatrix_row_25_w_clkbuf_0[43]/Q[4] swmatrix_row_25_w_clkbuf_0[43]/Q[5] swmatrix_row_25_w_clkbuf_0[43]/Q[6]
+ swmatrix_row_25_w_clkbuf_0[43]/Q[7] swmatrix_row_25_w_clkbuf_0[43]/Q[8] swmatrix_row_25_w_clkbuf_0[43]/Q[9]
+ swmatrix_row_25_w_clkbuf_0[43]/Q[10] swmatrix_row_25_w_clkbuf_0[43]/Q[11] swmatrix_row_25_w_clkbuf_0[43]/Q[12]
+ swmatrix_row_25_w_clkbuf_0[43]/Q[13] swmatrix_row_25_w_clkbuf_0[43]/Q[14] swmatrix_row_25_w_clkbuf_0[43]/Q[15]
+ swmatrix_row_25_w_clkbuf_0[43]/Q[16] swmatrix_row_25_w_clkbuf_0[43]/Q[17] swmatrix_row_25_w_clkbuf_0[43]/Q[18]
+ swmatrix_row_25_w_clkbuf_0[43]/Q[19] swmatrix_row_25_w_clkbuf_0[43]/Q[20] swmatrix_row_25_w_clkbuf_0[43]/Q[21]
+ swmatrix_row_25_w_clkbuf_0[43]/Q[22] swmatrix_row_25_w_clkbuf_0[43]/Q[23] swmatrix_row_25_w_clkbuf_0[43]/Q[24]
+ swmatrix_row_25_w_clkbuf_0[42]/D_in PIN[87] swmatrix_row_25_w_clkbuf_0[43]/Q[1]
+ swmatrix_row_25_w_clkbuf_0[43]/Q[2] swmatrix_row_25_w_clkbuf_0[43]/D_in PHI_1_in
+ BUS[20] swmatrix_row_25_w_clkbuf_0[43]/ShiftReg_row_25_0/DFF_2phase_1$1_0[23]/gf180mcu_fd_sc_mcu9t5v0__latq_1$2_1/Q
+ BUS[23] enable_in BUS[22] BUS[25] PHI_2_in BUS[8] BUS[11] BUS[2] BUS[18] VSSd BUS[14]
+ BUS[5] swmatrix_row_25_w_clkbuf
Xswmatrix_row_25_w_clkbuf_0[44] VDDd BUS[24] BUS[21] BUS[19] BUS[17] BUS[16] BUS[15]
+ BUS[13] BUS[12] BUS[10] BUS[9] BUS[7] BUS[6] BUS[4] BUS[3] BUS[1] swmatrix_row_25_w_clkbuf_0[44]/Q[3]
+ swmatrix_row_25_w_clkbuf_0[44]/Q[4] swmatrix_row_25_w_clkbuf_0[44]/Q[5] swmatrix_row_25_w_clkbuf_0[44]/Q[6]
+ swmatrix_row_25_w_clkbuf_0[44]/Q[7] swmatrix_row_25_w_clkbuf_0[44]/Q[8] swmatrix_row_25_w_clkbuf_0[44]/Q[9]
+ swmatrix_row_25_w_clkbuf_0[44]/Q[10] swmatrix_row_25_w_clkbuf_0[44]/Q[11] swmatrix_row_25_w_clkbuf_0[44]/Q[12]
+ swmatrix_row_25_w_clkbuf_0[44]/Q[13] swmatrix_row_25_w_clkbuf_0[44]/Q[14] swmatrix_row_25_w_clkbuf_0[44]/Q[15]
+ swmatrix_row_25_w_clkbuf_0[44]/Q[16] swmatrix_row_25_w_clkbuf_0[44]/Q[17] swmatrix_row_25_w_clkbuf_0[44]/Q[18]
+ swmatrix_row_25_w_clkbuf_0[44]/Q[19] swmatrix_row_25_w_clkbuf_0[44]/Q[20] swmatrix_row_25_w_clkbuf_0[44]/Q[21]
+ swmatrix_row_25_w_clkbuf_0[44]/Q[22] swmatrix_row_25_w_clkbuf_0[44]/Q[23] swmatrix_row_25_w_clkbuf_0[44]/Q[24]
+ swmatrix_row_25_w_clkbuf_0[43]/D_in PIN[86] swmatrix_row_25_w_clkbuf_0[44]/Q[1]
+ swmatrix_row_25_w_clkbuf_0[44]/Q[2] swmatrix_row_25_w_clkbuf_0[44]/D_in PHI_1_in
+ BUS[20] swmatrix_row_25_w_clkbuf_0[44]/ShiftReg_row_25_0/DFF_2phase_1$1_0[23]/gf180mcu_fd_sc_mcu9t5v0__latq_1$2_1/Q
+ BUS[23] enable_in BUS[22] BUS[25] PHI_2_in BUS[8] BUS[11] BUS[2] BUS[18] VSSd BUS[14]
+ BUS[5] swmatrix_row_25_w_clkbuf
Xswmatrix_row_25_w_clkbuf_0[45] VDDd BUS[24] BUS[21] BUS[19] BUS[17] BUS[16] BUS[15]
+ BUS[13] BUS[12] BUS[10] BUS[9] BUS[7] BUS[6] BUS[4] BUS[3] BUS[1] swmatrix_row_25_w_clkbuf_0[45]/Q[3]
+ swmatrix_row_25_w_clkbuf_0[45]/Q[4] swmatrix_row_25_w_clkbuf_0[45]/Q[5] swmatrix_row_25_w_clkbuf_0[45]/Q[6]
+ swmatrix_row_25_w_clkbuf_0[45]/Q[7] swmatrix_row_25_w_clkbuf_0[45]/Q[8] swmatrix_row_25_w_clkbuf_0[45]/Q[9]
+ swmatrix_row_25_w_clkbuf_0[45]/Q[10] swmatrix_row_25_w_clkbuf_0[45]/Q[11] swmatrix_row_25_w_clkbuf_0[45]/Q[12]
+ swmatrix_row_25_w_clkbuf_0[45]/Q[13] swmatrix_row_25_w_clkbuf_0[45]/Q[14] swmatrix_row_25_w_clkbuf_0[45]/Q[15]
+ swmatrix_row_25_w_clkbuf_0[45]/Q[16] swmatrix_row_25_w_clkbuf_0[45]/Q[17] swmatrix_row_25_w_clkbuf_0[45]/Q[18]
+ swmatrix_row_25_w_clkbuf_0[45]/Q[19] swmatrix_row_25_w_clkbuf_0[45]/Q[20] swmatrix_row_25_w_clkbuf_0[45]/Q[21]
+ swmatrix_row_25_w_clkbuf_0[45]/Q[22] swmatrix_row_25_w_clkbuf_0[45]/Q[23] swmatrix_row_25_w_clkbuf_0[45]/Q[24]
+ swmatrix_row_25_w_clkbuf_0[44]/D_in PIN[85] swmatrix_row_25_w_clkbuf_0[45]/Q[1]
+ swmatrix_row_25_w_clkbuf_0[45]/Q[2] swmatrix_row_25_w_clkbuf_0[45]/D_in PHI_1_in
+ BUS[20] swmatrix_row_25_w_clkbuf_0[45]/ShiftReg_row_25_0/DFF_2phase_1$1_0[23]/gf180mcu_fd_sc_mcu9t5v0__latq_1$2_1/Q
+ BUS[23] enable_in BUS[22] BUS[25] PHI_2_in BUS[8] BUS[11] BUS[2] BUS[18] VSSd BUS[14]
+ BUS[5] swmatrix_row_25_w_clkbuf
Xswmatrix_row_25_w_clkbuf_0[46] VDDd BUS[24] BUS[21] BUS[19] BUS[17] BUS[16] BUS[15]
+ BUS[13] BUS[12] BUS[10] BUS[9] BUS[7] BUS[6] BUS[4] BUS[3] BUS[1] swmatrix_row_25_w_clkbuf_0[46]/Q[3]
+ swmatrix_row_25_w_clkbuf_0[46]/Q[4] swmatrix_row_25_w_clkbuf_0[46]/Q[5] swmatrix_row_25_w_clkbuf_0[46]/Q[6]
+ swmatrix_row_25_w_clkbuf_0[46]/Q[7] swmatrix_row_25_w_clkbuf_0[46]/Q[8] swmatrix_row_25_w_clkbuf_0[46]/Q[9]
+ swmatrix_row_25_w_clkbuf_0[46]/Q[10] swmatrix_row_25_w_clkbuf_0[46]/Q[11] swmatrix_row_25_w_clkbuf_0[46]/Q[12]
+ swmatrix_row_25_w_clkbuf_0[46]/Q[13] swmatrix_row_25_w_clkbuf_0[46]/Q[14] swmatrix_row_25_w_clkbuf_0[46]/Q[15]
+ swmatrix_row_25_w_clkbuf_0[46]/Q[16] swmatrix_row_25_w_clkbuf_0[46]/Q[17] swmatrix_row_25_w_clkbuf_0[46]/Q[18]
+ swmatrix_row_25_w_clkbuf_0[46]/Q[19] swmatrix_row_25_w_clkbuf_0[46]/Q[20] swmatrix_row_25_w_clkbuf_0[46]/Q[21]
+ swmatrix_row_25_w_clkbuf_0[46]/Q[22] swmatrix_row_25_w_clkbuf_0[46]/Q[23] swmatrix_row_25_w_clkbuf_0[46]/Q[24]
+ swmatrix_row_25_w_clkbuf_0[45]/D_in PIN[84] swmatrix_row_25_w_clkbuf_0[46]/Q[1]
+ swmatrix_row_25_w_clkbuf_0[46]/Q[2] swmatrix_row_25_w_clkbuf_0[46]/D_in PHI_1_in
+ BUS[20] swmatrix_row_25_w_clkbuf_0[46]/ShiftReg_row_25_0/DFF_2phase_1$1_0[23]/gf180mcu_fd_sc_mcu9t5v0__latq_1$2_1/Q
+ BUS[23] enable_in BUS[22] BUS[25] PHI_2_in BUS[8] BUS[11] BUS[2] BUS[18] VSSd BUS[14]
+ BUS[5] swmatrix_row_25_w_clkbuf
Xswmatrix_row_25_w_clkbuf_0[47] VDDd BUS[24] BUS[21] BUS[19] BUS[17] BUS[16] BUS[15]
+ BUS[13] BUS[12] BUS[10] BUS[9] BUS[7] BUS[6] BUS[4] BUS[3] BUS[1] swmatrix_row_25_w_clkbuf_0[47]/Q[3]
+ swmatrix_row_25_w_clkbuf_0[47]/Q[4] swmatrix_row_25_w_clkbuf_0[47]/Q[5] swmatrix_row_25_w_clkbuf_0[47]/Q[6]
+ swmatrix_row_25_w_clkbuf_0[47]/Q[7] swmatrix_row_25_w_clkbuf_0[47]/Q[8] swmatrix_row_25_w_clkbuf_0[47]/Q[9]
+ swmatrix_row_25_w_clkbuf_0[47]/Q[10] swmatrix_row_25_w_clkbuf_0[47]/Q[11] swmatrix_row_25_w_clkbuf_0[47]/Q[12]
+ swmatrix_row_25_w_clkbuf_0[47]/Q[13] swmatrix_row_25_w_clkbuf_0[47]/Q[14] swmatrix_row_25_w_clkbuf_0[47]/Q[15]
+ swmatrix_row_25_w_clkbuf_0[47]/Q[16] swmatrix_row_25_w_clkbuf_0[47]/Q[17] swmatrix_row_25_w_clkbuf_0[47]/Q[18]
+ swmatrix_row_25_w_clkbuf_0[47]/Q[19] swmatrix_row_25_w_clkbuf_0[47]/Q[20] swmatrix_row_25_w_clkbuf_0[47]/Q[21]
+ swmatrix_row_25_w_clkbuf_0[47]/Q[22] swmatrix_row_25_w_clkbuf_0[47]/Q[23] swmatrix_row_25_w_clkbuf_0[47]/Q[24]
+ swmatrix_row_25_w_clkbuf_0[46]/D_in PIN[83] swmatrix_row_25_w_clkbuf_0[47]/Q[1]
+ swmatrix_row_25_w_clkbuf_0[47]/Q[2] swmatrix_row_25_w_clkbuf_0[47]/D_in PHI_1_in
+ BUS[20] swmatrix_row_25_w_clkbuf_0[47]/ShiftReg_row_25_0/DFF_2phase_1$1_0[23]/gf180mcu_fd_sc_mcu9t5v0__latq_1$2_1/Q
+ BUS[23] enable_in BUS[22] BUS[25] PHI_2_in BUS[8] BUS[11] BUS[2] BUS[18] VSSd BUS[14]
+ BUS[5] swmatrix_row_25_w_clkbuf
Xswmatrix_row_25_w_clkbuf_0[48] VDDd BUS[24] BUS[21] BUS[19] BUS[17] BUS[16] BUS[15]
+ BUS[13] BUS[12] BUS[10] BUS[9] BUS[7] BUS[6] BUS[4] BUS[3] BUS[1] swmatrix_row_25_w_clkbuf_0[48]/Q[3]
+ swmatrix_row_25_w_clkbuf_0[48]/Q[4] swmatrix_row_25_w_clkbuf_0[48]/Q[5] swmatrix_row_25_w_clkbuf_0[48]/Q[6]
+ swmatrix_row_25_w_clkbuf_0[48]/Q[7] swmatrix_row_25_w_clkbuf_0[48]/Q[8] swmatrix_row_25_w_clkbuf_0[48]/Q[9]
+ swmatrix_row_25_w_clkbuf_0[48]/Q[10] swmatrix_row_25_w_clkbuf_0[48]/Q[11] swmatrix_row_25_w_clkbuf_0[48]/Q[12]
+ swmatrix_row_25_w_clkbuf_0[48]/Q[13] swmatrix_row_25_w_clkbuf_0[48]/Q[14] swmatrix_row_25_w_clkbuf_0[48]/Q[15]
+ swmatrix_row_25_w_clkbuf_0[48]/Q[16] swmatrix_row_25_w_clkbuf_0[48]/Q[17] swmatrix_row_25_w_clkbuf_0[48]/Q[18]
+ swmatrix_row_25_w_clkbuf_0[48]/Q[19] swmatrix_row_25_w_clkbuf_0[48]/Q[20] swmatrix_row_25_w_clkbuf_0[48]/Q[21]
+ swmatrix_row_25_w_clkbuf_0[48]/Q[22] swmatrix_row_25_w_clkbuf_0[48]/Q[23] swmatrix_row_25_w_clkbuf_0[48]/Q[24]
+ swmatrix_row_25_w_clkbuf_0[47]/D_in PIN[82] swmatrix_row_25_w_clkbuf_0[48]/Q[1]
+ swmatrix_row_25_w_clkbuf_0[48]/Q[2] swmatrix_row_25_w_clkbuf_0[48]/D_in PHI_1_in
+ BUS[20] swmatrix_row_25_w_clkbuf_0[48]/ShiftReg_row_25_0/DFF_2phase_1$1_0[23]/gf180mcu_fd_sc_mcu9t5v0__latq_1$2_1/Q
+ BUS[23] enable_in BUS[22] BUS[25] PHI_2_in BUS[8] BUS[11] BUS[2] BUS[18] VSSd BUS[14]
+ BUS[5] swmatrix_row_25_w_clkbuf
Xswmatrix_row_25_w_clkbuf_0[49] VDDd BUS[24] BUS[21] BUS[19] BUS[17] BUS[16] BUS[15]
+ BUS[13] BUS[12] BUS[10] BUS[9] BUS[7] BUS[6] BUS[4] BUS[3] BUS[1] swmatrix_row_25_w_clkbuf_0[49]/Q[3]
+ swmatrix_row_25_w_clkbuf_0[49]/Q[4] swmatrix_row_25_w_clkbuf_0[49]/Q[5] swmatrix_row_25_w_clkbuf_0[49]/Q[6]
+ swmatrix_row_25_w_clkbuf_0[49]/Q[7] swmatrix_row_25_w_clkbuf_0[49]/Q[8] swmatrix_row_25_w_clkbuf_0[49]/Q[9]
+ swmatrix_row_25_w_clkbuf_0[49]/Q[10] swmatrix_row_25_w_clkbuf_0[49]/Q[11] swmatrix_row_25_w_clkbuf_0[49]/Q[12]
+ swmatrix_row_25_w_clkbuf_0[49]/Q[13] swmatrix_row_25_w_clkbuf_0[49]/Q[14] swmatrix_row_25_w_clkbuf_0[49]/Q[15]
+ swmatrix_row_25_w_clkbuf_0[49]/Q[16] swmatrix_row_25_w_clkbuf_0[49]/Q[17] swmatrix_row_25_w_clkbuf_0[49]/Q[18]
+ swmatrix_row_25_w_clkbuf_0[49]/Q[19] swmatrix_row_25_w_clkbuf_0[49]/Q[20] swmatrix_row_25_w_clkbuf_0[49]/Q[21]
+ swmatrix_row_25_w_clkbuf_0[49]/Q[22] swmatrix_row_25_w_clkbuf_0[49]/Q[23] swmatrix_row_25_w_clkbuf_0[49]/Q[24]
+ swmatrix_row_25_w_clkbuf_0[48]/D_in PIN[81] swmatrix_row_25_w_clkbuf_0[49]/Q[1]
+ swmatrix_row_25_w_clkbuf_0[49]/Q[2] swmatrix_row_25_w_clkbuf_0[49]/D_in PHI_1_in
+ BUS[20] swmatrix_row_25_w_clkbuf_0[49]/ShiftReg_row_25_0/DFF_2phase_1$1_0[23]/gf180mcu_fd_sc_mcu9t5v0__latq_1$2_1/Q
+ BUS[23] enable_in BUS[22] BUS[25] PHI_2_in BUS[8] BUS[11] BUS[2] BUS[18] VSSd BUS[14]
+ BUS[5] swmatrix_row_25_w_clkbuf
Xswmatrix_row_25_w_clkbuf_0[50] VDDd BUS[24] BUS[21] BUS[19] BUS[17] BUS[16] BUS[15]
+ BUS[13] BUS[12] BUS[10] BUS[9] BUS[7] BUS[6] BUS[4] BUS[3] BUS[1] swmatrix_row_25_w_clkbuf_0[50]/Q[3]
+ swmatrix_row_25_w_clkbuf_0[50]/Q[4] swmatrix_row_25_w_clkbuf_0[50]/Q[5] swmatrix_row_25_w_clkbuf_0[50]/Q[6]
+ swmatrix_row_25_w_clkbuf_0[50]/Q[7] swmatrix_row_25_w_clkbuf_0[50]/Q[8] swmatrix_row_25_w_clkbuf_0[50]/Q[9]
+ swmatrix_row_25_w_clkbuf_0[50]/Q[10] swmatrix_row_25_w_clkbuf_0[50]/Q[11] swmatrix_row_25_w_clkbuf_0[50]/Q[12]
+ swmatrix_row_25_w_clkbuf_0[50]/Q[13] swmatrix_row_25_w_clkbuf_0[50]/Q[14] swmatrix_row_25_w_clkbuf_0[50]/Q[15]
+ swmatrix_row_25_w_clkbuf_0[50]/Q[16] swmatrix_row_25_w_clkbuf_0[50]/Q[17] swmatrix_row_25_w_clkbuf_0[50]/Q[18]
+ swmatrix_row_25_w_clkbuf_0[50]/Q[19] swmatrix_row_25_w_clkbuf_0[50]/Q[20] swmatrix_row_25_w_clkbuf_0[50]/Q[21]
+ swmatrix_row_25_w_clkbuf_0[50]/Q[22] swmatrix_row_25_w_clkbuf_0[50]/Q[23] swmatrix_row_25_w_clkbuf_0[50]/Q[24]
+ swmatrix_row_25_w_clkbuf_0[49]/D_in PIN[80] swmatrix_row_25_w_clkbuf_0[50]/Q[1]
+ swmatrix_row_25_w_clkbuf_0[50]/Q[2] swmatrix_row_25_w_clkbuf_0[50]/D_in PHI_1_in
+ BUS[20] swmatrix_row_25_w_clkbuf_0[50]/ShiftReg_row_25_0/DFF_2phase_1$1_0[23]/gf180mcu_fd_sc_mcu9t5v0__latq_1$2_1/Q
+ BUS[23] enable_in BUS[22] BUS[25] PHI_2_in BUS[8] BUS[11] BUS[2] BUS[18] VSSd BUS[14]
+ BUS[5] swmatrix_row_25_w_clkbuf
Xswmatrix_row_25_w_clkbuf_0[51] VDDd BUS[24] BUS[21] BUS[19] BUS[17] BUS[16] BUS[15]
+ BUS[13] BUS[12] BUS[10] BUS[9] BUS[7] BUS[6] BUS[4] BUS[3] BUS[1] swmatrix_row_25_w_clkbuf_0[51]/Q[3]
+ swmatrix_row_25_w_clkbuf_0[51]/Q[4] swmatrix_row_25_w_clkbuf_0[51]/Q[5] swmatrix_row_25_w_clkbuf_0[51]/Q[6]
+ swmatrix_row_25_w_clkbuf_0[51]/Q[7] swmatrix_row_25_w_clkbuf_0[51]/Q[8] swmatrix_row_25_w_clkbuf_0[51]/Q[9]
+ swmatrix_row_25_w_clkbuf_0[51]/Q[10] swmatrix_row_25_w_clkbuf_0[51]/Q[11] swmatrix_row_25_w_clkbuf_0[51]/Q[12]
+ swmatrix_row_25_w_clkbuf_0[51]/Q[13] swmatrix_row_25_w_clkbuf_0[51]/Q[14] swmatrix_row_25_w_clkbuf_0[51]/Q[15]
+ swmatrix_row_25_w_clkbuf_0[51]/Q[16] swmatrix_row_25_w_clkbuf_0[51]/Q[17] swmatrix_row_25_w_clkbuf_0[51]/Q[18]
+ swmatrix_row_25_w_clkbuf_0[51]/Q[19] swmatrix_row_25_w_clkbuf_0[51]/Q[20] swmatrix_row_25_w_clkbuf_0[51]/Q[21]
+ swmatrix_row_25_w_clkbuf_0[51]/Q[22] swmatrix_row_25_w_clkbuf_0[51]/Q[23] swmatrix_row_25_w_clkbuf_0[51]/Q[24]
+ swmatrix_row_25_w_clkbuf_0[50]/D_in PIN[79] swmatrix_row_25_w_clkbuf_0[51]/Q[1]
+ swmatrix_row_25_w_clkbuf_0[51]/Q[2] swmatrix_row_25_w_clkbuf_0[51]/D_in PHI_1_in
+ BUS[20] swmatrix_row_25_w_clkbuf_0[51]/ShiftReg_row_25_0/DFF_2phase_1$1_0[23]/gf180mcu_fd_sc_mcu9t5v0__latq_1$2_1/Q
+ BUS[23] enable_in BUS[22] BUS[25] PHI_2_in BUS[8] BUS[11] BUS[2] BUS[18] VSSd BUS[14]
+ BUS[5] swmatrix_row_25_w_clkbuf
Xswmatrix_row_25_w_clkbuf_0[52] VDDd BUS[24] BUS[21] BUS[19] BUS[17] BUS[16] BUS[15]
+ BUS[13] BUS[12] BUS[10] BUS[9] BUS[7] BUS[6] BUS[4] BUS[3] BUS[1] swmatrix_row_25_w_clkbuf_0[52]/Q[3]
+ swmatrix_row_25_w_clkbuf_0[52]/Q[4] swmatrix_row_25_w_clkbuf_0[52]/Q[5] swmatrix_row_25_w_clkbuf_0[52]/Q[6]
+ swmatrix_row_25_w_clkbuf_0[52]/Q[7] swmatrix_row_25_w_clkbuf_0[52]/Q[8] swmatrix_row_25_w_clkbuf_0[52]/Q[9]
+ swmatrix_row_25_w_clkbuf_0[52]/Q[10] swmatrix_row_25_w_clkbuf_0[52]/Q[11] swmatrix_row_25_w_clkbuf_0[52]/Q[12]
+ swmatrix_row_25_w_clkbuf_0[52]/Q[13] swmatrix_row_25_w_clkbuf_0[52]/Q[14] swmatrix_row_25_w_clkbuf_0[52]/Q[15]
+ swmatrix_row_25_w_clkbuf_0[52]/Q[16] swmatrix_row_25_w_clkbuf_0[52]/Q[17] swmatrix_row_25_w_clkbuf_0[52]/Q[18]
+ swmatrix_row_25_w_clkbuf_0[52]/Q[19] swmatrix_row_25_w_clkbuf_0[52]/Q[20] swmatrix_row_25_w_clkbuf_0[52]/Q[21]
+ swmatrix_row_25_w_clkbuf_0[52]/Q[22] swmatrix_row_25_w_clkbuf_0[52]/Q[23] swmatrix_row_25_w_clkbuf_0[52]/Q[24]
+ swmatrix_row_25_w_clkbuf_0[51]/D_in PIN[78] swmatrix_row_25_w_clkbuf_0[52]/Q[1]
+ swmatrix_row_25_w_clkbuf_0[52]/Q[2] swmatrix_row_25_w_clkbuf_0[52]/D_in PHI_1_in
+ BUS[20] swmatrix_row_25_w_clkbuf_0[52]/ShiftReg_row_25_0/DFF_2phase_1$1_0[23]/gf180mcu_fd_sc_mcu9t5v0__latq_1$2_1/Q
+ BUS[23] enable_in BUS[22] BUS[25] PHI_2_in BUS[8] BUS[11] BUS[2] BUS[18] VSSd BUS[14]
+ BUS[5] swmatrix_row_25_w_clkbuf
Xswmatrix_row_25_w_clkbuf_0[53] VDDd BUS[24] BUS[21] BUS[19] BUS[17] BUS[16] BUS[15]
+ BUS[13] BUS[12] BUS[10] BUS[9] BUS[7] BUS[6] BUS[4] BUS[3] BUS[1] swmatrix_row_25_w_clkbuf_0[53]/Q[3]
+ swmatrix_row_25_w_clkbuf_0[53]/Q[4] swmatrix_row_25_w_clkbuf_0[53]/Q[5] swmatrix_row_25_w_clkbuf_0[53]/Q[6]
+ swmatrix_row_25_w_clkbuf_0[53]/Q[7] swmatrix_row_25_w_clkbuf_0[53]/Q[8] swmatrix_row_25_w_clkbuf_0[53]/Q[9]
+ swmatrix_row_25_w_clkbuf_0[53]/Q[10] swmatrix_row_25_w_clkbuf_0[53]/Q[11] swmatrix_row_25_w_clkbuf_0[53]/Q[12]
+ swmatrix_row_25_w_clkbuf_0[53]/Q[13] swmatrix_row_25_w_clkbuf_0[53]/Q[14] swmatrix_row_25_w_clkbuf_0[53]/Q[15]
+ swmatrix_row_25_w_clkbuf_0[53]/Q[16] swmatrix_row_25_w_clkbuf_0[53]/Q[17] swmatrix_row_25_w_clkbuf_0[53]/Q[18]
+ swmatrix_row_25_w_clkbuf_0[53]/Q[19] swmatrix_row_25_w_clkbuf_0[53]/Q[20] swmatrix_row_25_w_clkbuf_0[53]/Q[21]
+ swmatrix_row_25_w_clkbuf_0[53]/Q[22] swmatrix_row_25_w_clkbuf_0[53]/Q[23] swmatrix_row_25_w_clkbuf_0[53]/Q[24]
+ swmatrix_row_25_w_clkbuf_0[52]/D_in PIN[77] swmatrix_row_25_w_clkbuf_0[53]/Q[1]
+ swmatrix_row_25_w_clkbuf_0[53]/Q[2] swmatrix_row_25_w_clkbuf_0[53]/D_in PHI_1_in
+ BUS[20] swmatrix_row_25_w_clkbuf_0[53]/ShiftReg_row_25_0/DFF_2phase_1$1_0[23]/gf180mcu_fd_sc_mcu9t5v0__latq_1$2_1/Q
+ BUS[23] enable_in BUS[22] BUS[25] PHI_2_in BUS[8] BUS[11] BUS[2] BUS[18] VSSd BUS[14]
+ BUS[5] swmatrix_row_25_w_clkbuf
Xswmatrix_row_25_w_clkbuf_0[54] VDDd BUS[24] BUS[21] BUS[19] BUS[17] BUS[16] BUS[15]
+ BUS[13] BUS[12] BUS[10] BUS[9] BUS[7] BUS[6] BUS[4] BUS[3] BUS[1] swmatrix_row_25_w_clkbuf_0[54]/Q[3]
+ swmatrix_row_25_w_clkbuf_0[54]/Q[4] swmatrix_row_25_w_clkbuf_0[54]/Q[5] swmatrix_row_25_w_clkbuf_0[54]/Q[6]
+ swmatrix_row_25_w_clkbuf_0[54]/Q[7] swmatrix_row_25_w_clkbuf_0[54]/Q[8] swmatrix_row_25_w_clkbuf_0[54]/Q[9]
+ swmatrix_row_25_w_clkbuf_0[54]/Q[10] swmatrix_row_25_w_clkbuf_0[54]/Q[11] swmatrix_row_25_w_clkbuf_0[54]/Q[12]
+ swmatrix_row_25_w_clkbuf_0[54]/Q[13] swmatrix_row_25_w_clkbuf_0[54]/Q[14] swmatrix_row_25_w_clkbuf_0[54]/Q[15]
+ swmatrix_row_25_w_clkbuf_0[54]/Q[16] swmatrix_row_25_w_clkbuf_0[54]/Q[17] swmatrix_row_25_w_clkbuf_0[54]/Q[18]
+ swmatrix_row_25_w_clkbuf_0[54]/Q[19] swmatrix_row_25_w_clkbuf_0[54]/Q[20] swmatrix_row_25_w_clkbuf_0[54]/Q[21]
+ swmatrix_row_25_w_clkbuf_0[54]/Q[22] swmatrix_row_25_w_clkbuf_0[54]/Q[23] swmatrix_row_25_w_clkbuf_0[54]/Q[24]
+ swmatrix_row_25_w_clkbuf_0[53]/D_in PIN[76] swmatrix_row_25_w_clkbuf_0[54]/Q[1]
+ swmatrix_row_25_w_clkbuf_0[54]/Q[2] swmatrix_row_25_w_clkbuf_0[54]/D_in PHI_1_in
+ BUS[20] swmatrix_row_25_w_clkbuf_0[54]/ShiftReg_row_25_0/DFF_2phase_1$1_0[23]/gf180mcu_fd_sc_mcu9t5v0__latq_1$2_1/Q
+ BUS[23] enable_in BUS[22] BUS[25] PHI_2_in BUS[8] BUS[11] BUS[2] BUS[18] VSSd BUS[14]
+ BUS[5] swmatrix_row_25_w_clkbuf
Xswmatrix_row_25_w_clkbuf_0[55] VDDd BUS[24] BUS[21] BUS[19] BUS[17] BUS[16] BUS[15]
+ BUS[13] BUS[12] BUS[10] BUS[9] BUS[7] BUS[6] BUS[4] BUS[3] BUS[1] swmatrix_row_25_w_clkbuf_0[55]/Q[3]
+ swmatrix_row_25_w_clkbuf_0[55]/Q[4] swmatrix_row_25_w_clkbuf_0[55]/Q[5] swmatrix_row_25_w_clkbuf_0[55]/Q[6]
+ swmatrix_row_25_w_clkbuf_0[55]/Q[7] swmatrix_row_25_w_clkbuf_0[55]/Q[8] swmatrix_row_25_w_clkbuf_0[55]/Q[9]
+ swmatrix_row_25_w_clkbuf_0[55]/Q[10] swmatrix_row_25_w_clkbuf_0[55]/Q[11] swmatrix_row_25_w_clkbuf_0[55]/Q[12]
+ swmatrix_row_25_w_clkbuf_0[55]/Q[13] swmatrix_row_25_w_clkbuf_0[55]/Q[14] swmatrix_row_25_w_clkbuf_0[55]/Q[15]
+ swmatrix_row_25_w_clkbuf_0[55]/Q[16] swmatrix_row_25_w_clkbuf_0[55]/Q[17] swmatrix_row_25_w_clkbuf_0[55]/Q[18]
+ swmatrix_row_25_w_clkbuf_0[55]/Q[19] swmatrix_row_25_w_clkbuf_0[55]/Q[20] swmatrix_row_25_w_clkbuf_0[55]/Q[21]
+ swmatrix_row_25_w_clkbuf_0[55]/Q[22] swmatrix_row_25_w_clkbuf_0[55]/Q[23] swmatrix_row_25_w_clkbuf_0[55]/Q[24]
+ swmatrix_row_25_w_clkbuf_0[54]/D_in PIN[75] swmatrix_row_25_w_clkbuf_0[55]/Q[1]
+ swmatrix_row_25_w_clkbuf_0[55]/Q[2] swmatrix_row_25_w_clkbuf_0[55]/D_in PHI_1_in
+ BUS[20] swmatrix_row_25_w_clkbuf_0[55]/ShiftReg_row_25_0/DFF_2phase_1$1_0[23]/gf180mcu_fd_sc_mcu9t5v0__latq_1$2_1/Q
+ BUS[23] enable_in BUS[22] BUS[25] PHI_2_in BUS[8] BUS[11] BUS[2] BUS[18] VSSd BUS[14]
+ BUS[5] swmatrix_row_25_w_clkbuf
Xswmatrix_row_25_w_clkbuf_0[56] VDDd BUS[24] BUS[21] BUS[19] BUS[17] BUS[16] BUS[15]
+ BUS[13] BUS[12] BUS[10] BUS[9] BUS[7] BUS[6] BUS[4] BUS[3] BUS[1] swmatrix_row_25_w_clkbuf_0[56]/Q[3]
+ swmatrix_row_25_w_clkbuf_0[56]/Q[4] swmatrix_row_25_w_clkbuf_0[56]/Q[5] swmatrix_row_25_w_clkbuf_0[56]/Q[6]
+ swmatrix_row_25_w_clkbuf_0[56]/Q[7] swmatrix_row_25_w_clkbuf_0[56]/Q[8] swmatrix_row_25_w_clkbuf_0[56]/Q[9]
+ swmatrix_row_25_w_clkbuf_0[56]/Q[10] swmatrix_row_25_w_clkbuf_0[56]/Q[11] swmatrix_row_25_w_clkbuf_0[56]/Q[12]
+ swmatrix_row_25_w_clkbuf_0[56]/Q[13] swmatrix_row_25_w_clkbuf_0[56]/Q[14] swmatrix_row_25_w_clkbuf_0[56]/Q[15]
+ swmatrix_row_25_w_clkbuf_0[56]/Q[16] swmatrix_row_25_w_clkbuf_0[56]/Q[17] swmatrix_row_25_w_clkbuf_0[56]/Q[18]
+ swmatrix_row_25_w_clkbuf_0[56]/Q[19] swmatrix_row_25_w_clkbuf_0[56]/Q[20] swmatrix_row_25_w_clkbuf_0[56]/Q[21]
+ swmatrix_row_25_w_clkbuf_0[56]/Q[22] swmatrix_row_25_w_clkbuf_0[56]/Q[23] swmatrix_row_25_w_clkbuf_0[56]/Q[24]
+ swmatrix_row_25_w_clkbuf_0[55]/D_in PIN[74] swmatrix_row_25_w_clkbuf_0[56]/Q[1]
+ swmatrix_row_25_w_clkbuf_0[56]/Q[2] swmatrix_row_25_w_clkbuf_0[56]/D_in PHI_1_in
+ BUS[20] swmatrix_row_25_w_clkbuf_0[56]/ShiftReg_row_25_0/DFF_2phase_1$1_0[23]/gf180mcu_fd_sc_mcu9t5v0__latq_1$2_1/Q
+ BUS[23] enable_in BUS[22] BUS[25] PHI_2_in BUS[8] BUS[11] BUS[2] BUS[18] VSSd BUS[14]
+ BUS[5] swmatrix_row_25_w_clkbuf
Xswmatrix_row_25_w_clkbuf_0[57] VDDd BUS[24] BUS[21] BUS[19] BUS[17] BUS[16] BUS[15]
+ BUS[13] BUS[12] BUS[10] BUS[9] BUS[7] BUS[6] BUS[4] BUS[3] BUS[1] swmatrix_row_25_w_clkbuf_0[57]/Q[3]
+ swmatrix_row_25_w_clkbuf_0[57]/Q[4] swmatrix_row_25_w_clkbuf_0[57]/Q[5] swmatrix_row_25_w_clkbuf_0[57]/Q[6]
+ swmatrix_row_25_w_clkbuf_0[57]/Q[7] swmatrix_row_25_w_clkbuf_0[57]/Q[8] swmatrix_row_25_w_clkbuf_0[57]/Q[9]
+ swmatrix_row_25_w_clkbuf_0[57]/Q[10] swmatrix_row_25_w_clkbuf_0[57]/Q[11] swmatrix_row_25_w_clkbuf_0[57]/Q[12]
+ swmatrix_row_25_w_clkbuf_0[57]/Q[13] swmatrix_row_25_w_clkbuf_0[57]/Q[14] swmatrix_row_25_w_clkbuf_0[57]/Q[15]
+ swmatrix_row_25_w_clkbuf_0[57]/Q[16] swmatrix_row_25_w_clkbuf_0[57]/Q[17] swmatrix_row_25_w_clkbuf_0[57]/Q[18]
+ swmatrix_row_25_w_clkbuf_0[57]/Q[19] swmatrix_row_25_w_clkbuf_0[57]/Q[20] swmatrix_row_25_w_clkbuf_0[57]/Q[21]
+ swmatrix_row_25_w_clkbuf_0[57]/Q[22] swmatrix_row_25_w_clkbuf_0[57]/Q[23] swmatrix_row_25_w_clkbuf_0[57]/Q[24]
+ swmatrix_row_25_w_clkbuf_0[56]/D_in PIN[73] swmatrix_row_25_w_clkbuf_0[57]/Q[1]
+ swmatrix_row_25_w_clkbuf_0[57]/Q[2] swmatrix_row_25_w_clkbuf_0[57]/D_in PHI_1_in
+ BUS[20] swmatrix_row_25_w_clkbuf_0[57]/ShiftReg_row_25_0/DFF_2phase_1$1_0[23]/gf180mcu_fd_sc_mcu9t5v0__latq_1$2_1/Q
+ BUS[23] enable_in BUS[22] BUS[25] PHI_2_in BUS[8] BUS[11] BUS[2] BUS[18] VSSd BUS[14]
+ BUS[5] swmatrix_row_25_w_clkbuf
Xswmatrix_row_25_w_clkbuf_0[58] VDDd BUS[24] BUS[21] BUS[19] BUS[17] BUS[16] BUS[15]
+ BUS[13] BUS[12] BUS[10] BUS[9] BUS[7] BUS[6] BUS[4] BUS[3] BUS[1] swmatrix_row_25_w_clkbuf_0[58]/Q[3]
+ swmatrix_row_25_w_clkbuf_0[58]/Q[4] swmatrix_row_25_w_clkbuf_0[58]/Q[5] swmatrix_row_25_w_clkbuf_0[58]/Q[6]
+ swmatrix_row_25_w_clkbuf_0[58]/Q[7] swmatrix_row_25_w_clkbuf_0[58]/Q[8] swmatrix_row_25_w_clkbuf_0[58]/Q[9]
+ swmatrix_row_25_w_clkbuf_0[58]/Q[10] swmatrix_row_25_w_clkbuf_0[58]/Q[11] swmatrix_row_25_w_clkbuf_0[58]/Q[12]
+ swmatrix_row_25_w_clkbuf_0[58]/Q[13] swmatrix_row_25_w_clkbuf_0[58]/Q[14] swmatrix_row_25_w_clkbuf_0[58]/Q[15]
+ swmatrix_row_25_w_clkbuf_0[58]/Q[16] swmatrix_row_25_w_clkbuf_0[58]/Q[17] swmatrix_row_25_w_clkbuf_0[58]/Q[18]
+ swmatrix_row_25_w_clkbuf_0[58]/Q[19] swmatrix_row_25_w_clkbuf_0[58]/Q[20] swmatrix_row_25_w_clkbuf_0[58]/Q[21]
+ swmatrix_row_25_w_clkbuf_0[58]/Q[22] swmatrix_row_25_w_clkbuf_0[58]/Q[23] swmatrix_row_25_w_clkbuf_0[58]/Q[24]
+ swmatrix_row_25_w_clkbuf_0[57]/D_in PIN[72] swmatrix_row_25_w_clkbuf_0[58]/Q[1]
+ swmatrix_row_25_w_clkbuf_0[58]/Q[2] swmatrix_row_25_w_clkbuf_0[58]/D_in PHI_1_in
+ BUS[20] swmatrix_row_25_w_clkbuf_0[58]/ShiftReg_row_25_0/DFF_2phase_1$1_0[23]/gf180mcu_fd_sc_mcu9t5v0__latq_1$2_1/Q
+ BUS[23] enable_in BUS[22] BUS[25] PHI_2_in BUS[8] BUS[11] BUS[2] BUS[18] VSSd BUS[14]
+ BUS[5] swmatrix_row_25_w_clkbuf
Xswmatrix_row_25_w_clkbuf_0[59] VDDd BUS[24] BUS[21] BUS[19] BUS[17] BUS[16] BUS[15]
+ BUS[13] BUS[12] BUS[10] BUS[9] BUS[7] BUS[6] BUS[4] BUS[3] BUS[1] swmatrix_row_25_w_clkbuf_0[59]/Q[3]
+ swmatrix_row_25_w_clkbuf_0[59]/Q[4] swmatrix_row_25_w_clkbuf_0[59]/Q[5] swmatrix_row_25_w_clkbuf_0[59]/Q[6]
+ swmatrix_row_25_w_clkbuf_0[59]/Q[7] swmatrix_row_25_w_clkbuf_0[59]/Q[8] swmatrix_row_25_w_clkbuf_0[59]/Q[9]
+ swmatrix_row_25_w_clkbuf_0[59]/Q[10] swmatrix_row_25_w_clkbuf_0[59]/Q[11] swmatrix_row_25_w_clkbuf_0[59]/Q[12]
+ swmatrix_row_25_w_clkbuf_0[59]/Q[13] swmatrix_row_25_w_clkbuf_0[59]/Q[14] swmatrix_row_25_w_clkbuf_0[59]/Q[15]
+ swmatrix_row_25_w_clkbuf_0[59]/Q[16] swmatrix_row_25_w_clkbuf_0[59]/Q[17] swmatrix_row_25_w_clkbuf_0[59]/Q[18]
+ swmatrix_row_25_w_clkbuf_0[59]/Q[19] swmatrix_row_25_w_clkbuf_0[59]/Q[20] swmatrix_row_25_w_clkbuf_0[59]/Q[21]
+ swmatrix_row_25_w_clkbuf_0[59]/Q[22] swmatrix_row_25_w_clkbuf_0[59]/Q[23] swmatrix_row_25_w_clkbuf_0[59]/Q[24]
+ swmatrix_row_25_w_clkbuf_0[58]/D_in PIN[71] swmatrix_row_25_w_clkbuf_0[59]/Q[1]
+ swmatrix_row_25_w_clkbuf_0[59]/Q[2] swmatrix_row_25_w_clkbuf_0[59]/D_in PHI_1_in
+ BUS[20] swmatrix_row_25_w_clkbuf_0[59]/ShiftReg_row_25_0/DFF_2phase_1$1_0[23]/gf180mcu_fd_sc_mcu9t5v0__latq_1$2_1/Q
+ BUS[23] enable_in BUS[22] BUS[25] PHI_2_in BUS[8] BUS[11] BUS[2] BUS[18] VSSd BUS[14]
+ BUS[5] swmatrix_row_25_w_clkbuf
Xswmatrix_row_25_w_clkbuf_0[60] VDDd BUS[24] BUS[21] BUS[19] BUS[17] BUS[16] BUS[15]
+ BUS[13] BUS[12] BUS[10] BUS[9] BUS[7] BUS[6] BUS[4] BUS[3] BUS[1] swmatrix_row_25_w_clkbuf_0[60]/Q[3]
+ swmatrix_row_25_w_clkbuf_0[60]/Q[4] swmatrix_row_25_w_clkbuf_0[60]/Q[5] swmatrix_row_25_w_clkbuf_0[60]/Q[6]
+ swmatrix_row_25_w_clkbuf_0[60]/Q[7] swmatrix_row_25_w_clkbuf_0[60]/Q[8] swmatrix_row_25_w_clkbuf_0[60]/Q[9]
+ swmatrix_row_25_w_clkbuf_0[60]/Q[10] swmatrix_row_25_w_clkbuf_0[60]/Q[11] swmatrix_row_25_w_clkbuf_0[60]/Q[12]
+ swmatrix_row_25_w_clkbuf_0[60]/Q[13] swmatrix_row_25_w_clkbuf_0[60]/Q[14] swmatrix_row_25_w_clkbuf_0[60]/Q[15]
+ swmatrix_row_25_w_clkbuf_0[60]/Q[16] swmatrix_row_25_w_clkbuf_0[60]/Q[17] swmatrix_row_25_w_clkbuf_0[60]/Q[18]
+ swmatrix_row_25_w_clkbuf_0[60]/Q[19] swmatrix_row_25_w_clkbuf_0[60]/Q[20] swmatrix_row_25_w_clkbuf_0[60]/Q[21]
+ swmatrix_row_25_w_clkbuf_0[60]/Q[22] swmatrix_row_25_w_clkbuf_0[60]/Q[23] swmatrix_row_25_w_clkbuf_0[60]/Q[24]
+ swmatrix_row_25_w_clkbuf_0[59]/D_in PIN[70] swmatrix_row_25_w_clkbuf_0[60]/Q[1]
+ swmatrix_row_25_w_clkbuf_0[60]/Q[2] swmatrix_row_25_w_clkbuf_0[60]/D_in PHI_1_in
+ BUS[20] swmatrix_row_25_w_clkbuf_0[60]/ShiftReg_row_25_0/DFF_2phase_1$1_0[23]/gf180mcu_fd_sc_mcu9t5v0__latq_1$2_1/Q
+ BUS[23] enable_in BUS[22] BUS[25] PHI_2_in BUS[8] BUS[11] BUS[2] BUS[18] VSSd BUS[14]
+ BUS[5] swmatrix_row_25_w_clkbuf
Xswmatrix_row_25_w_clkbuf_0[61] VDDd BUS[24] BUS[21] BUS[19] BUS[17] BUS[16] BUS[15]
+ BUS[13] BUS[12] BUS[10] BUS[9] BUS[7] BUS[6] BUS[4] BUS[3] BUS[1] swmatrix_row_25_w_clkbuf_0[61]/Q[3]
+ swmatrix_row_25_w_clkbuf_0[61]/Q[4] swmatrix_row_25_w_clkbuf_0[61]/Q[5] swmatrix_row_25_w_clkbuf_0[61]/Q[6]
+ swmatrix_row_25_w_clkbuf_0[61]/Q[7] swmatrix_row_25_w_clkbuf_0[61]/Q[8] swmatrix_row_25_w_clkbuf_0[61]/Q[9]
+ swmatrix_row_25_w_clkbuf_0[61]/Q[10] swmatrix_row_25_w_clkbuf_0[61]/Q[11] swmatrix_row_25_w_clkbuf_0[61]/Q[12]
+ swmatrix_row_25_w_clkbuf_0[61]/Q[13] swmatrix_row_25_w_clkbuf_0[61]/Q[14] swmatrix_row_25_w_clkbuf_0[61]/Q[15]
+ swmatrix_row_25_w_clkbuf_0[61]/Q[16] swmatrix_row_25_w_clkbuf_0[61]/Q[17] swmatrix_row_25_w_clkbuf_0[61]/Q[18]
+ swmatrix_row_25_w_clkbuf_0[61]/Q[19] swmatrix_row_25_w_clkbuf_0[61]/Q[20] swmatrix_row_25_w_clkbuf_0[61]/Q[21]
+ swmatrix_row_25_w_clkbuf_0[61]/Q[22] swmatrix_row_25_w_clkbuf_0[61]/Q[23] swmatrix_row_25_w_clkbuf_0[61]/Q[24]
+ swmatrix_row_25_w_clkbuf_0[60]/D_in PIN[69] swmatrix_row_25_w_clkbuf_0[61]/Q[1]
+ swmatrix_row_25_w_clkbuf_0[61]/Q[2] swmatrix_row_25_w_clkbuf_0[61]/D_in PHI_1_in
+ BUS[20] swmatrix_row_25_w_clkbuf_0[61]/ShiftReg_row_25_0/DFF_2phase_1$1_0[23]/gf180mcu_fd_sc_mcu9t5v0__latq_1$2_1/Q
+ BUS[23] enable_in BUS[22] BUS[25] PHI_2_in BUS[8] BUS[11] BUS[2] BUS[18] VSSd BUS[14]
+ BUS[5] swmatrix_row_25_w_clkbuf
Xswmatrix_row_25_w_clkbuf_0[62] VDDd BUS[24] BUS[21] BUS[19] BUS[17] BUS[16] BUS[15]
+ BUS[13] BUS[12] BUS[10] BUS[9] BUS[7] BUS[6] BUS[4] BUS[3] BUS[1] swmatrix_row_25_w_clkbuf_0[62]/Q[3]
+ swmatrix_row_25_w_clkbuf_0[62]/Q[4] swmatrix_row_25_w_clkbuf_0[62]/Q[5] swmatrix_row_25_w_clkbuf_0[62]/Q[6]
+ swmatrix_row_25_w_clkbuf_0[62]/Q[7] swmatrix_row_25_w_clkbuf_0[62]/Q[8] swmatrix_row_25_w_clkbuf_0[62]/Q[9]
+ swmatrix_row_25_w_clkbuf_0[62]/Q[10] swmatrix_row_25_w_clkbuf_0[62]/Q[11] swmatrix_row_25_w_clkbuf_0[62]/Q[12]
+ swmatrix_row_25_w_clkbuf_0[62]/Q[13] swmatrix_row_25_w_clkbuf_0[62]/Q[14] swmatrix_row_25_w_clkbuf_0[62]/Q[15]
+ swmatrix_row_25_w_clkbuf_0[62]/Q[16] swmatrix_row_25_w_clkbuf_0[62]/Q[17] swmatrix_row_25_w_clkbuf_0[62]/Q[18]
+ swmatrix_row_25_w_clkbuf_0[62]/Q[19] swmatrix_row_25_w_clkbuf_0[62]/Q[20] swmatrix_row_25_w_clkbuf_0[62]/Q[21]
+ swmatrix_row_25_w_clkbuf_0[62]/Q[22] swmatrix_row_25_w_clkbuf_0[62]/Q[23] swmatrix_row_25_w_clkbuf_0[62]/Q[24]
+ swmatrix_row_25_w_clkbuf_0[61]/D_in PIN[68] swmatrix_row_25_w_clkbuf_0[62]/Q[1]
+ swmatrix_row_25_w_clkbuf_0[62]/Q[2] swmatrix_row_25_w_clkbuf_0[62]/D_in PHI_1_in
+ BUS[20] swmatrix_row_25_w_clkbuf_0[62]/ShiftReg_row_25_0/DFF_2phase_1$1_0[23]/gf180mcu_fd_sc_mcu9t5v0__latq_1$2_1/Q
+ BUS[23] enable_in BUS[22] BUS[25] PHI_2_in BUS[8] BUS[11] BUS[2] BUS[18] VSSd BUS[14]
+ BUS[5] swmatrix_row_25_w_clkbuf
Xswmatrix_row_25_w_clkbuf_0[63] VDDd BUS[24] BUS[21] BUS[19] BUS[17] BUS[16] BUS[15]
+ BUS[13] BUS[12] BUS[10] BUS[9] BUS[7] BUS[6] BUS[4] BUS[3] BUS[1] swmatrix_row_25_w_clkbuf_0[63]/Q[3]
+ swmatrix_row_25_w_clkbuf_0[63]/Q[4] swmatrix_row_25_w_clkbuf_0[63]/Q[5] swmatrix_row_25_w_clkbuf_0[63]/Q[6]
+ swmatrix_row_25_w_clkbuf_0[63]/Q[7] swmatrix_row_25_w_clkbuf_0[63]/Q[8] swmatrix_row_25_w_clkbuf_0[63]/Q[9]
+ swmatrix_row_25_w_clkbuf_0[63]/Q[10] swmatrix_row_25_w_clkbuf_0[63]/Q[11] swmatrix_row_25_w_clkbuf_0[63]/Q[12]
+ swmatrix_row_25_w_clkbuf_0[63]/Q[13] swmatrix_row_25_w_clkbuf_0[63]/Q[14] swmatrix_row_25_w_clkbuf_0[63]/Q[15]
+ swmatrix_row_25_w_clkbuf_0[63]/Q[16] swmatrix_row_25_w_clkbuf_0[63]/Q[17] swmatrix_row_25_w_clkbuf_0[63]/Q[18]
+ swmatrix_row_25_w_clkbuf_0[63]/Q[19] swmatrix_row_25_w_clkbuf_0[63]/Q[20] swmatrix_row_25_w_clkbuf_0[63]/Q[21]
+ swmatrix_row_25_w_clkbuf_0[63]/Q[22] swmatrix_row_25_w_clkbuf_0[63]/Q[23] swmatrix_row_25_w_clkbuf_0[63]/Q[24]
+ swmatrix_row_25_w_clkbuf_0[62]/D_in PIN[67] swmatrix_row_25_w_clkbuf_0[63]/Q[1]
+ swmatrix_row_25_w_clkbuf_0[63]/Q[2] swmatrix_row_25_w_clkbuf_0[63]/D_in PHI_1_in
+ BUS[20] swmatrix_row_25_w_clkbuf_0[63]/ShiftReg_row_25_0/DFF_2phase_1$1_0[23]/gf180mcu_fd_sc_mcu9t5v0__latq_1$2_1/Q
+ BUS[23] enable_in BUS[22] BUS[25] PHI_2_in BUS[8] BUS[11] BUS[2] BUS[18] VSSd BUS[14]
+ BUS[5] swmatrix_row_25_w_clkbuf
Xswmatrix_row_25_w_clkbuf_0[64] VDDd BUS[24] BUS[21] BUS[19] BUS[17] BUS[16] BUS[15]
+ BUS[13] BUS[12] BUS[10] BUS[9] BUS[7] BUS[6] BUS[4] BUS[3] BUS[1] swmatrix_row_25_w_clkbuf_0[64]/Q[3]
+ swmatrix_row_25_w_clkbuf_0[64]/Q[4] swmatrix_row_25_w_clkbuf_0[64]/Q[5] swmatrix_row_25_w_clkbuf_0[64]/Q[6]
+ swmatrix_row_25_w_clkbuf_0[64]/Q[7] swmatrix_row_25_w_clkbuf_0[64]/Q[8] swmatrix_row_25_w_clkbuf_0[64]/Q[9]
+ swmatrix_row_25_w_clkbuf_0[64]/Q[10] swmatrix_row_25_w_clkbuf_0[64]/Q[11] swmatrix_row_25_w_clkbuf_0[64]/Q[12]
+ swmatrix_row_25_w_clkbuf_0[64]/Q[13] swmatrix_row_25_w_clkbuf_0[64]/Q[14] swmatrix_row_25_w_clkbuf_0[64]/Q[15]
+ swmatrix_row_25_w_clkbuf_0[64]/Q[16] swmatrix_row_25_w_clkbuf_0[64]/Q[17] swmatrix_row_25_w_clkbuf_0[64]/Q[18]
+ swmatrix_row_25_w_clkbuf_0[64]/Q[19] swmatrix_row_25_w_clkbuf_0[64]/Q[20] swmatrix_row_25_w_clkbuf_0[64]/Q[21]
+ swmatrix_row_25_w_clkbuf_0[64]/Q[22] swmatrix_row_25_w_clkbuf_0[64]/Q[23] swmatrix_row_25_w_clkbuf_0[64]/Q[24]
+ swmatrix_row_25_w_clkbuf_0[63]/D_in PIN[66] swmatrix_row_25_w_clkbuf_0[64]/Q[1]
+ swmatrix_row_25_w_clkbuf_0[64]/Q[2] swmatrix_row_25_w_clkbuf_0[64]/D_in PHI_1_in
+ BUS[20] swmatrix_row_25_w_clkbuf_0[64]/ShiftReg_row_25_0/DFF_2phase_1$1_0[23]/gf180mcu_fd_sc_mcu9t5v0__latq_1$2_1/Q
+ BUS[23] enable_in BUS[22] BUS[25] PHI_2_in BUS[8] BUS[11] BUS[2] BUS[18] VSSd BUS[14]
+ BUS[5] swmatrix_row_25_w_clkbuf
Xswmatrix_row_25_w_clkbuf_0[65] VDDd BUS[24] BUS[21] BUS[19] BUS[17] BUS[16] BUS[15]
+ BUS[13] BUS[12] BUS[10] BUS[9] BUS[7] BUS[6] BUS[4] BUS[3] BUS[1] swmatrix_row_25_w_clkbuf_0[65]/Q[3]
+ swmatrix_row_25_w_clkbuf_0[65]/Q[4] swmatrix_row_25_w_clkbuf_0[65]/Q[5] swmatrix_row_25_w_clkbuf_0[65]/Q[6]
+ swmatrix_row_25_w_clkbuf_0[65]/Q[7] swmatrix_row_25_w_clkbuf_0[65]/Q[8] swmatrix_row_25_w_clkbuf_0[65]/Q[9]
+ swmatrix_row_25_w_clkbuf_0[65]/Q[10] swmatrix_row_25_w_clkbuf_0[65]/Q[11] swmatrix_row_25_w_clkbuf_0[65]/Q[12]
+ swmatrix_row_25_w_clkbuf_0[65]/Q[13] swmatrix_row_25_w_clkbuf_0[65]/Q[14] swmatrix_row_25_w_clkbuf_0[65]/Q[15]
+ swmatrix_row_25_w_clkbuf_0[65]/Q[16] swmatrix_row_25_w_clkbuf_0[65]/Q[17] swmatrix_row_25_w_clkbuf_0[65]/Q[18]
+ swmatrix_row_25_w_clkbuf_0[65]/Q[19] swmatrix_row_25_w_clkbuf_0[65]/Q[20] swmatrix_row_25_w_clkbuf_0[65]/Q[21]
+ swmatrix_row_25_w_clkbuf_0[65]/Q[22] swmatrix_row_25_w_clkbuf_0[65]/Q[23] swmatrix_row_25_w_clkbuf_0[65]/Q[24]
+ swmatrix_row_25_w_clkbuf_0[64]/D_in PIN[65] swmatrix_row_25_w_clkbuf_0[65]/Q[1]
+ swmatrix_row_25_w_clkbuf_0[65]/Q[2] swmatrix_row_25_w_clkbuf_0[65]/D_in PHI_1_in
+ BUS[20] swmatrix_row_25_w_clkbuf_0[65]/ShiftReg_row_25_0/DFF_2phase_1$1_0[23]/gf180mcu_fd_sc_mcu9t5v0__latq_1$2_1/Q
+ BUS[23] enable_in BUS[22] BUS[25] PHI_2_in BUS[8] BUS[11] BUS[2] BUS[18] VSSd BUS[14]
+ BUS[5] swmatrix_row_25_w_clkbuf
Xswmatrix_row_25_w_clkbuf_0[66] VDDd BUS[24] BUS[21] BUS[19] BUS[17] BUS[16] BUS[15]
+ BUS[13] BUS[12] BUS[10] BUS[9] BUS[7] BUS[6] BUS[4] BUS[3] BUS[1] swmatrix_row_25_w_clkbuf_0[66]/Q[3]
+ swmatrix_row_25_w_clkbuf_0[66]/Q[4] swmatrix_row_25_w_clkbuf_0[66]/Q[5] swmatrix_row_25_w_clkbuf_0[66]/Q[6]
+ swmatrix_row_25_w_clkbuf_0[66]/Q[7] swmatrix_row_25_w_clkbuf_0[66]/Q[8] swmatrix_row_25_w_clkbuf_0[66]/Q[9]
+ swmatrix_row_25_w_clkbuf_0[66]/Q[10] swmatrix_row_25_w_clkbuf_0[66]/Q[11] swmatrix_row_25_w_clkbuf_0[66]/Q[12]
+ swmatrix_row_25_w_clkbuf_0[66]/Q[13] swmatrix_row_25_w_clkbuf_0[66]/Q[14] swmatrix_row_25_w_clkbuf_0[66]/Q[15]
+ swmatrix_row_25_w_clkbuf_0[66]/Q[16] swmatrix_row_25_w_clkbuf_0[66]/Q[17] swmatrix_row_25_w_clkbuf_0[66]/Q[18]
+ swmatrix_row_25_w_clkbuf_0[66]/Q[19] swmatrix_row_25_w_clkbuf_0[66]/Q[20] swmatrix_row_25_w_clkbuf_0[66]/Q[21]
+ swmatrix_row_25_w_clkbuf_0[66]/Q[22] swmatrix_row_25_w_clkbuf_0[66]/Q[23] swmatrix_row_25_w_clkbuf_0[66]/Q[24]
+ swmatrix_row_25_w_clkbuf_0[65]/D_in PIN[64] swmatrix_row_25_w_clkbuf_0[66]/Q[1]
+ swmatrix_row_25_w_clkbuf_0[66]/Q[2] swmatrix_row_25_w_clkbuf_0[66]/D_in PHI_1_in
+ BUS[20] swmatrix_row_25_w_clkbuf_0[66]/ShiftReg_row_25_0/DFF_2phase_1$1_0[23]/gf180mcu_fd_sc_mcu9t5v0__latq_1$2_1/Q
+ BUS[23] enable_in BUS[22] BUS[25] PHI_2_in BUS[8] BUS[11] BUS[2] BUS[18] VSSd BUS[14]
+ BUS[5] swmatrix_row_25_w_clkbuf
Xswmatrix_row_25_w_clkbuf_0[67] VDDd BUS[24] BUS[21] BUS[19] BUS[17] BUS[16] BUS[15]
+ BUS[13] BUS[12] BUS[10] BUS[9] BUS[7] BUS[6] BUS[4] BUS[3] BUS[1] swmatrix_row_25_w_clkbuf_0[67]/Q[3]
+ swmatrix_row_25_w_clkbuf_0[67]/Q[4] swmatrix_row_25_w_clkbuf_0[67]/Q[5] swmatrix_row_25_w_clkbuf_0[67]/Q[6]
+ swmatrix_row_25_w_clkbuf_0[67]/Q[7] swmatrix_row_25_w_clkbuf_0[67]/Q[8] swmatrix_row_25_w_clkbuf_0[67]/Q[9]
+ swmatrix_row_25_w_clkbuf_0[67]/Q[10] swmatrix_row_25_w_clkbuf_0[67]/Q[11] swmatrix_row_25_w_clkbuf_0[67]/Q[12]
+ swmatrix_row_25_w_clkbuf_0[67]/Q[13] swmatrix_row_25_w_clkbuf_0[67]/Q[14] swmatrix_row_25_w_clkbuf_0[67]/Q[15]
+ swmatrix_row_25_w_clkbuf_0[67]/Q[16] swmatrix_row_25_w_clkbuf_0[67]/Q[17] swmatrix_row_25_w_clkbuf_0[67]/Q[18]
+ swmatrix_row_25_w_clkbuf_0[67]/Q[19] swmatrix_row_25_w_clkbuf_0[67]/Q[20] swmatrix_row_25_w_clkbuf_0[67]/Q[21]
+ swmatrix_row_25_w_clkbuf_0[67]/Q[22] swmatrix_row_25_w_clkbuf_0[67]/Q[23] swmatrix_row_25_w_clkbuf_0[67]/Q[24]
+ swmatrix_row_25_w_clkbuf_0[66]/D_in PIN[63] swmatrix_row_25_w_clkbuf_0[67]/Q[1]
+ swmatrix_row_25_w_clkbuf_0[67]/Q[2] swmatrix_row_25_w_clkbuf_0[67]/D_in PHI_1_in
+ BUS[20] swmatrix_row_25_w_clkbuf_0[67]/ShiftReg_row_25_0/DFF_2phase_1$1_0[23]/gf180mcu_fd_sc_mcu9t5v0__latq_1$2_1/Q
+ BUS[23] enable_in BUS[22] BUS[25] PHI_2_in BUS[8] BUS[11] BUS[2] BUS[18] VSSd BUS[14]
+ BUS[5] swmatrix_row_25_w_clkbuf
Xswmatrix_row_25_w_clkbuf_0[68] VDDd BUS[24] BUS[21] BUS[19] BUS[17] BUS[16] BUS[15]
+ BUS[13] BUS[12] BUS[10] BUS[9] BUS[7] BUS[6] BUS[4] BUS[3] BUS[1] swmatrix_row_25_w_clkbuf_0[68]/Q[3]
+ swmatrix_row_25_w_clkbuf_0[68]/Q[4] swmatrix_row_25_w_clkbuf_0[68]/Q[5] swmatrix_row_25_w_clkbuf_0[68]/Q[6]
+ swmatrix_row_25_w_clkbuf_0[68]/Q[7] swmatrix_row_25_w_clkbuf_0[68]/Q[8] swmatrix_row_25_w_clkbuf_0[68]/Q[9]
+ swmatrix_row_25_w_clkbuf_0[68]/Q[10] swmatrix_row_25_w_clkbuf_0[68]/Q[11] swmatrix_row_25_w_clkbuf_0[68]/Q[12]
+ swmatrix_row_25_w_clkbuf_0[68]/Q[13] swmatrix_row_25_w_clkbuf_0[68]/Q[14] swmatrix_row_25_w_clkbuf_0[68]/Q[15]
+ swmatrix_row_25_w_clkbuf_0[68]/Q[16] swmatrix_row_25_w_clkbuf_0[68]/Q[17] swmatrix_row_25_w_clkbuf_0[68]/Q[18]
+ swmatrix_row_25_w_clkbuf_0[68]/Q[19] swmatrix_row_25_w_clkbuf_0[68]/Q[20] swmatrix_row_25_w_clkbuf_0[68]/Q[21]
+ swmatrix_row_25_w_clkbuf_0[68]/Q[22] swmatrix_row_25_w_clkbuf_0[68]/Q[23] swmatrix_row_25_w_clkbuf_0[68]/Q[24]
+ swmatrix_row_25_w_clkbuf_0[67]/D_in PIN[62] swmatrix_row_25_w_clkbuf_0[68]/Q[1]
+ swmatrix_row_25_w_clkbuf_0[68]/Q[2] swmatrix_row_25_w_clkbuf_0[68]/D_in PHI_1_in
+ BUS[20] swmatrix_row_25_w_clkbuf_0[68]/ShiftReg_row_25_0/DFF_2phase_1$1_0[23]/gf180mcu_fd_sc_mcu9t5v0__latq_1$2_1/Q
+ BUS[23] enable_in BUS[22] BUS[25] PHI_2_in BUS[8] BUS[11] BUS[2] BUS[18] VSSd BUS[14]
+ BUS[5] swmatrix_row_25_w_clkbuf
Xswmatrix_row_25_w_clkbuf_0[69] VDDd BUS[24] BUS[21] BUS[19] BUS[17] BUS[16] BUS[15]
+ BUS[13] BUS[12] BUS[10] BUS[9] BUS[7] BUS[6] BUS[4] BUS[3] BUS[1] swmatrix_row_25_w_clkbuf_0[69]/Q[3]
+ swmatrix_row_25_w_clkbuf_0[69]/Q[4] swmatrix_row_25_w_clkbuf_0[69]/Q[5] swmatrix_row_25_w_clkbuf_0[69]/Q[6]
+ swmatrix_row_25_w_clkbuf_0[69]/Q[7] swmatrix_row_25_w_clkbuf_0[69]/Q[8] swmatrix_row_25_w_clkbuf_0[69]/Q[9]
+ swmatrix_row_25_w_clkbuf_0[69]/Q[10] swmatrix_row_25_w_clkbuf_0[69]/Q[11] swmatrix_row_25_w_clkbuf_0[69]/Q[12]
+ swmatrix_row_25_w_clkbuf_0[69]/Q[13] swmatrix_row_25_w_clkbuf_0[69]/Q[14] swmatrix_row_25_w_clkbuf_0[69]/Q[15]
+ swmatrix_row_25_w_clkbuf_0[69]/Q[16] swmatrix_row_25_w_clkbuf_0[69]/Q[17] swmatrix_row_25_w_clkbuf_0[69]/Q[18]
+ swmatrix_row_25_w_clkbuf_0[69]/Q[19] swmatrix_row_25_w_clkbuf_0[69]/Q[20] swmatrix_row_25_w_clkbuf_0[69]/Q[21]
+ swmatrix_row_25_w_clkbuf_0[69]/Q[22] swmatrix_row_25_w_clkbuf_0[69]/Q[23] swmatrix_row_25_w_clkbuf_0[69]/Q[24]
+ swmatrix_row_25_w_clkbuf_0[68]/D_in PIN[61] swmatrix_row_25_w_clkbuf_0[69]/Q[1]
+ swmatrix_row_25_w_clkbuf_0[69]/Q[2] swmatrix_row_25_w_clkbuf_0[69]/D_in PHI_1_in
+ BUS[20] swmatrix_row_25_w_clkbuf_0[69]/ShiftReg_row_25_0/DFF_2phase_1$1_0[23]/gf180mcu_fd_sc_mcu9t5v0__latq_1$2_1/Q
+ BUS[23] enable_in BUS[22] BUS[25] PHI_2_in BUS[8] BUS[11] BUS[2] BUS[18] VSSd BUS[14]
+ BUS[5] swmatrix_row_25_w_clkbuf
Xswmatrix_row_25_w_clkbuf_0[70] VDDd BUS[24] BUS[21] BUS[19] BUS[17] BUS[16] BUS[15]
+ BUS[13] BUS[12] BUS[10] BUS[9] BUS[7] BUS[6] BUS[4] BUS[3] BUS[1] swmatrix_row_25_w_clkbuf_0[70]/Q[3]
+ swmatrix_row_25_w_clkbuf_0[70]/Q[4] swmatrix_row_25_w_clkbuf_0[70]/Q[5] swmatrix_row_25_w_clkbuf_0[70]/Q[6]
+ swmatrix_row_25_w_clkbuf_0[70]/Q[7] swmatrix_row_25_w_clkbuf_0[70]/Q[8] swmatrix_row_25_w_clkbuf_0[70]/Q[9]
+ swmatrix_row_25_w_clkbuf_0[70]/Q[10] swmatrix_row_25_w_clkbuf_0[70]/Q[11] swmatrix_row_25_w_clkbuf_0[70]/Q[12]
+ swmatrix_row_25_w_clkbuf_0[70]/Q[13] swmatrix_row_25_w_clkbuf_0[70]/Q[14] swmatrix_row_25_w_clkbuf_0[70]/Q[15]
+ swmatrix_row_25_w_clkbuf_0[70]/Q[16] swmatrix_row_25_w_clkbuf_0[70]/Q[17] swmatrix_row_25_w_clkbuf_0[70]/Q[18]
+ swmatrix_row_25_w_clkbuf_0[70]/Q[19] swmatrix_row_25_w_clkbuf_0[70]/Q[20] swmatrix_row_25_w_clkbuf_0[70]/Q[21]
+ swmatrix_row_25_w_clkbuf_0[70]/Q[22] swmatrix_row_25_w_clkbuf_0[70]/Q[23] swmatrix_row_25_w_clkbuf_0[70]/Q[24]
+ swmatrix_row_25_w_clkbuf_0[69]/D_in PIN[60] swmatrix_row_25_w_clkbuf_0[70]/Q[1]
+ swmatrix_row_25_w_clkbuf_0[70]/Q[2] swmatrix_row_25_w_clkbuf_0[70]/D_in PHI_1_in
+ BUS[20] swmatrix_row_25_w_clkbuf_0[70]/ShiftReg_row_25_0/DFF_2phase_1$1_0[23]/gf180mcu_fd_sc_mcu9t5v0__latq_1$2_1/Q
+ BUS[23] enable_in BUS[22] BUS[25] PHI_2_in BUS[8] BUS[11] BUS[2] BUS[18] VSSd BUS[14]
+ BUS[5] swmatrix_row_25_w_clkbuf
Xswmatrix_row_25_w_clkbuf_0[71] VDDd BUS[24] BUS[21] BUS[19] BUS[17] BUS[16] BUS[15]
+ BUS[13] BUS[12] BUS[10] BUS[9] BUS[7] BUS[6] BUS[4] BUS[3] BUS[1] swmatrix_row_25_w_clkbuf_0[71]/Q[3]
+ swmatrix_row_25_w_clkbuf_0[71]/Q[4] swmatrix_row_25_w_clkbuf_0[71]/Q[5] swmatrix_row_25_w_clkbuf_0[71]/Q[6]
+ swmatrix_row_25_w_clkbuf_0[71]/Q[7] swmatrix_row_25_w_clkbuf_0[71]/Q[8] swmatrix_row_25_w_clkbuf_0[71]/Q[9]
+ swmatrix_row_25_w_clkbuf_0[71]/Q[10] swmatrix_row_25_w_clkbuf_0[71]/Q[11] swmatrix_row_25_w_clkbuf_0[71]/Q[12]
+ swmatrix_row_25_w_clkbuf_0[71]/Q[13] swmatrix_row_25_w_clkbuf_0[71]/Q[14] swmatrix_row_25_w_clkbuf_0[71]/Q[15]
+ swmatrix_row_25_w_clkbuf_0[71]/Q[16] swmatrix_row_25_w_clkbuf_0[71]/Q[17] swmatrix_row_25_w_clkbuf_0[71]/Q[18]
+ swmatrix_row_25_w_clkbuf_0[71]/Q[19] swmatrix_row_25_w_clkbuf_0[71]/Q[20] swmatrix_row_25_w_clkbuf_0[71]/Q[21]
+ swmatrix_row_25_w_clkbuf_0[71]/Q[22] swmatrix_row_25_w_clkbuf_0[71]/Q[23] swmatrix_row_25_w_clkbuf_0[71]/Q[24]
+ swmatrix_row_25_w_clkbuf_0[70]/D_in PIN[59] swmatrix_row_25_w_clkbuf_0[71]/Q[1]
+ swmatrix_row_25_w_clkbuf_0[71]/Q[2] swmatrix_row_25_w_clkbuf_0[71]/D_in PHI_1_in
+ BUS[20] swmatrix_row_25_w_clkbuf_0[71]/ShiftReg_row_25_0/DFF_2phase_1$1_0[23]/gf180mcu_fd_sc_mcu9t5v0__latq_1$2_1/Q
+ BUS[23] enable_in BUS[22] BUS[25] PHI_2_in BUS[8] BUS[11] BUS[2] BUS[18] VSSd BUS[14]
+ BUS[5] swmatrix_row_25_w_clkbuf
Xswmatrix_row_25_w_clkbuf_0[72] VDDd BUS[24] BUS[21] BUS[19] BUS[17] BUS[16] BUS[15]
+ BUS[13] BUS[12] BUS[10] BUS[9] BUS[7] BUS[6] BUS[4] BUS[3] BUS[1] swmatrix_row_25_w_clkbuf_0[72]/Q[3]
+ swmatrix_row_25_w_clkbuf_0[72]/Q[4] swmatrix_row_25_w_clkbuf_0[72]/Q[5] swmatrix_row_25_w_clkbuf_0[72]/Q[6]
+ swmatrix_row_25_w_clkbuf_0[72]/Q[7] swmatrix_row_25_w_clkbuf_0[72]/Q[8] swmatrix_row_25_w_clkbuf_0[72]/Q[9]
+ swmatrix_row_25_w_clkbuf_0[72]/Q[10] swmatrix_row_25_w_clkbuf_0[72]/Q[11] swmatrix_row_25_w_clkbuf_0[72]/Q[12]
+ swmatrix_row_25_w_clkbuf_0[72]/Q[13] swmatrix_row_25_w_clkbuf_0[72]/Q[14] swmatrix_row_25_w_clkbuf_0[72]/Q[15]
+ swmatrix_row_25_w_clkbuf_0[72]/Q[16] swmatrix_row_25_w_clkbuf_0[72]/Q[17] swmatrix_row_25_w_clkbuf_0[72]/Q[18]
+ swmatrix_row_25_w_clkbuf_0[72]/Q[19] swmatrix_row_25_w_clkbuf_0[72]/Q[20] swmatrix_row_25_w_clkbuf_0[72]/Q[21]
+ swmatrix_row_25_w_clkbuf_0[72]/Q[22] swmatrix_row_25_w_clkbuf_0[72]/Q[23] swmatrix_row_25_w_clkbuf_0[72]/Q[24]
+ swmatrix_row_25_w_clkbuf_0[71]/D_in PIN[58] swmatrix_row_25_w_clkbuf_0[72]/Q[1]
+ swmatrix_row_25_w_clkbuf_0[72]/Q[2] swmatrix_row_25_w_clkbuf_0[72]/D_in PHI_1_in
+ BUS[20] swmatrix_row_25_w_clkbuf_0[72]/ShiftReg_row_25_0/DFF_2phase_1$1_0[23]/gf180mcu_fd_sc_mcu9t5v0__latq_1$2_1/Q
+ BUS[23] enable_in BUS[22] BUS[25] PHI_2_in BUS[8] BUS[11] BUS[2] BUS[18] VSSd BUS[14]
+ BUS[5] swmatrix_row_25_w_clkbuf
Xswmatrix_row_25_w_clkbuf_0[73] VDDd BUS[24] BUS[21] BUS[19] BUS[17] BUS[16] BUS[15]
+ BUS[13] BUS[12] BUS[10] BUS[9] BUS[7] BUS[6] BUS[4] BUS[3] BUS[1] swmatrix_row_25_w_clkbuf_0[73]/Q[3]
+ swmatrix_row_25_w_clkbuf_0[73]/Q[4] swmatrix_row_25_w_clkbuf_0[73]/Q[5] swmatrix_row_25_w_clkbuf_0[73]/Q[6]
+ swmatrix_row_25_w_clkbuf_0[73]/Q[7] swmatrix_row_25_w_clkbuf_0[73]/Q[8] swmatrix_row_25_w_clkbuf_0[73]/Q[9]
+ swmatrix_row_25_w_clkbuf_0[73]/Q[10] swmatrix_row_25_w_clkbuf_0[73]/Q[11] swmatrix_row_25_w_clkbuf_0[73]/Q[12]
+ swmatrix_row_25_w_clkbuf_0[73]/Q[13] swmatrix_row_25_w_clkbuf_0[73]/Q[14] swmatrix_row_25_w_clkbuf_0[73]/Q[15]
+ swmatrix_row_25_w_clkbuf_0[73]/Q[16] swmatrix_row_25_w_clkbuf_0[73]/Q[17] swmatrix_row_25_w_clkbuf_0[73]/Q[18]
+ swmatrix_row_25_w_clkbuf_0[73]/Q[19] swmatrix_row_25_w_clkbuf_0[73]/Q[20] swmatrix_row_25_w_clkbuf_0[73]/Q[21]
+ swmatrix_row_25_w_clkbuf_0[73]/Q[22] swmatrix_row_25_w_clkbuf_0[73]/Q[23] swmatrix_row_25_w_clkbuf_0[73]/Q[24]
+ swmatrix_row_25_w_clkbuf_0[72]/D_in PIN[57] swmatrix_row_25_w_clkbuf_0[73]/Q[1]
+ swmatrix_row_25_w_clkbuf_0[73]/Q[2] swmatrix_row_25_w_clkbuf_0[73]/D_in PHI_1_in
+ BUS[20] swmatrix_row_25_w_clkbuf_0[73]/ShiftReg_row_25_0/DFF_2phase_1$1_0[23]/gf180mcu_fd_sc_mcu9t5v0__latq_1$2_1/Q
+ BUS[23] enable_in BUS[22] BUS[25] PHI_2_in BUS[8] BUS[11] BUS[2] BUS[18] VSSd BUS[14]
+ BUS[5] swmatrix_row_25_w_clkbuf
Xswmatrix_row_25_w_clkbuf_0[74] VDDd BUS[24] BUS[21] BUS[19] BUS[17] BUS[16] BUS[15]
+ BUS[13] BUS[12] BUS[10] BUS[9] BUS[7] BUS[6] BUS[4] BUS[3] BUS[1] swmatrix_row_25_w_clkbuf_0[74]/Q[3]
+ swmatrix_row_25_w_clkbuf_0[74]/Q[4] swmatrix_row_25_w_clkbuf_0[74]/Q[5] swmatrix_row_25_w_clkbuf_0[74]/Q[6]
+ swmatrix_row_25_w_clkbuf_0[74]/Q[7] swmatrix_row_25_w_clkbuf_0[74]/Q[8] swmatrix_row_25_w_clkbuf_0[74]/Q[9]
+ swmatrix_row_25_w_clkbuf_0[74]/Q[10] swmatrix_row_25_w_clkbuf_0[74]/Q[11] swmatrix_row_25_w_clkbuf_0[74]/Q[12]
+ swmatrix_row_25_w_clkbuf_0[74]/Q[13] swmatrix_row_25_w_clkbuf_0[74]/Q[14] swmatrix_row_25_w_clkbuf_0[74]/Q[15]
+ swmatrix_row_25_w_clkbuf_0[74]/Q[16] swmatrix_row_25_w_clkbuf_0[74]/Q[17] swmatrix_row_25_w_clkbuf_0[74]/Q[18]
+ swmatrix_row_25_w_clkbuf_0[74]/Q[19] swmatrix_row_25_w_clkbuf_0[74]/Q[20] swmatrix_row_25_w_clkbuf_0[74]/Q[21]
+ swmatrix_row_25_w_clkbuf_0[74]/Q[22] swmatrix_row_25_w_clkbuf_0[74]/Q[23] swmatrix_row_25_w_clkbuf_0[74]/Q[24]
+ swmatrix_row_25_w_clkbuf_0[73]/D_in PIN[56] swmatrix_row_25_w_clkbuf_0[74]/Q[1]
+ swmatrix_row_25_w_clkbuf_0[74]/Q[2] swmatrix_row_25_w_clkbuf_0[74]/D_in PHI_1_in
+ BUS[20] swmatrix_row_25_w_clkbuf_0[74]/ShiftReg_row_25_0/DFF_2phase_1$1_0[23]/gf180mcu_fd_sc_mcu9t5v0__latq_1$2_1/Q
+ BUS[23] enable_in BUS[22] BUS[25] PHI_2_in BUS[8] BUS[11] BUS[2] BUS[18] VSSd BUS[14]
+ BUS[5] swmatrix_row_25_w_clkbuf
Xswmatrix_row_25_w_clkbuf_0[75] VDDd BUS[24] BUS[21] BUS[19] BUS[17] BUS[16] BUS[15]
+ BUS[13] BUS[12] BUS[10] BUS[9] BUS[7] BUS[6] BUS[4] BUS[3] BUS[1] swmatrix_row_25_w_clkbuf_0[75]/Q[3]
+ swmatrix_row_25_w_clkbuf_0[75]/Q[4] swmatrix_row_25_w_clkbuf_0[75]/Q[5] swmatrix_row_25_w_clkbuf_0[75]/Q[6]
+ swmatrix_row_25_w_clkbuf_0[75]/Q[7] swmatrix_row_25_w_clkbuf_0[75]/Q[8] swmatrix_row_25_w_clkbuf_0[75]/Q[9]
+ swmatrix_row_25_w_clkbuf_0[75]/Q[10] swmatrix_row_25_w_clkbuf_0[75]/Q[11] swmatrix_row_25_w_clkbuf_0[75]/Q[12]
+ swmatrix_row_25_w_clkbuf_0[75]/Q[13] swmatrix_row_25_w_clkbuf_0[75]/Q[14] swmatrix_row_25_w_clkbuf_0[75]/Q[15]
+ swmatrix_row_25_w_clkbuf_0[75]/Q[16] swmatrix_row_25_w_clkbuf_0[75]/Q[17] swmatrix_row_25_w_clkbuf_0[75]/Q[18]
+ swmatrix_row_25_w_clkbuf_0[75]/Q[19] swmatrix_row_25_w_clkbuf_0[75]/Q[20] swmatrix_row_25_w_clkbuf_0[75]/Q[21]
+ swmatrix_row_25_w_clkbuf_0[75]/Q[22] swmatrix_row_25_w_clkbuf_0[75]/Q[23] swmatrix_row_25_w_clkbuf_0[75]/Q[24]
+ swmatrix_row_25_w_clkbuf_0[74]/D_in PIN[55] swmatrix_row_25_w_clkbuf_0[75]/Q[1]
+ swmatrix_row_25_w_clkbuf_0[75]/Q[2] swmatrix_row_25_w_clkbuf_0[75]/D_in PHI_1_in
+ BUS[20] swmatrix_row_25_w_clkbuf_0[75]/ShiftReg_row_25_0/DFF_2phase_1$1_0[23]/gf180mcu_fd_sc_mcu9t5v0__latq_1$2_1/Q
+ BUS[23] enable_in BUS[22] BUS[25] PHI_2_in BUS[8] BUS[11] BUS[2] BUS[18] VSSd BUS[14]
+ BUS[5] swmatrix_row_25_w_clkbuf
Xswmatrix_row_25_w_clkbuf_0[76] VDDd BUS[24] BUS[21] BUS[19] BUS[17] BUS[16] BUS[15]
+ BUS[13] BUS[12] BUS[10] BUS[9] BUS[7] BUS[6] BUS[4] BUS[3] BUS[1] swmatrix_row_25_w_clkbuf_0[76]/Q[3]
+ swmatrix_row_25_w_clkbuf_0[76]/Q[4] swmatrix_row_25_w_clkbuf_0[76]/Q[5] swmatrix_row_25_w_clkbuf_0[76]/Q[6]
+ swmatrix_row_25_w_clkbuf_0[76]/Q[7] swmatrix_row_25_w_clkbuf_0[76]/Q[8] swmatrix_row_25_w_clkbuf_0[76]/Q[9]
+ swmatrix_row_25_w_clkbuf_0[76]/Q[10] swmatrix_row_25_w_clkbuf_0[76]/Q[11] swmatrix_row_25_w_clkbuf_0[76]/Q[12]
+ swmatrix_row_25_w_clkbuf_0[76]/Q[13] swmatrix_row_25_w_clkbuf_0[76]/Q[14] swmatrix_row_25_w_clkbuf_0[76]/Q[15]
+ swmatrix_row_25_w_clkbuf_0[76]/Q[16] swmatrix_row_25_w_clkbuf_0[76]/Q[17] swmatrix_row_25_w_clkbuf_0[76]/Q[18]
+ swmatrix_row_25_w_clkbuf_0[76]/Q[19] swmatrix_row_25_w_clkbuf_0[76]/Q[20] swmatrix_row_25_w_clkbuf_0[76]/Q[21]
+ swmatrix_row_25_w_clkbuf_0[76]/Q[22] swmatrix_row_25_w_clkbuf_0[76]/Q[23] swmatrix_row_25_w_clkbuf_0[76]/Q[24]
+ swmatrix_row_25_w_clkbuf_0[75]/D_in PIN[54] swmatrix_row_25_w_clkbuf_0[76]/Q[1]
+ swmatrix_row_25_w_clkbuf_0[76]/Q[2] swmatrix_row_25_w_clkbuf_0[76]/D_in PHI_1_in
+ BUS[20] swmatrix_row_25_w_clkbuf_0[76]/ShiftReg_row_25_0/DFF_2phase_1$1_0[23]/gf180mcu_fd_sc_mcu9t5v0__latq_1$2_1/Q
+ BUS[23] enable_in BUS[22] BUS[25] PHI_2_in BUS[8] BUS[11] BUS[2] BUS[18] VSSd BUS[14]
+ BUS[5] swmatrix_row_25_w_clkbuf
Xswmatrix_row_25_w_clkbuf_0[77] VDDd BUS[24] BUS[21] BUS[19] BUS[17] BUS[16] BUS[15]
+ BUS[13] BUS[12] BUS[10] BUS[9] BUS[7] BUS[6] BUS[4] BUS[3] BUS[1] swmatrix_row_25_w_clkbuf_0[77]/Q[3]
+ swmatrix_row_25_w_clkbuf_0[77]/Q[4] swmatrix_row_25_w_clkbuf_0[77]/Q[5] swmatrix_row_25_w_clkbuf_0[77]/Q[6]
+ swmatrix_row_25_w_clkbuf_0[77]/Q[7] swmatrix_row_25_w_clkbuf_0[77]/Q[8] swmatrix_row_25_w_clkbuf_0[77]/Q[9]
+ swmatrix_row_25_w_clkbuf_0[77]/Q[10] swmatrix_row_25_w_clkbuf_0[77]/Q[11] swmatrix_row_25_w_clkbuf_0[77]/Q[12]
+ swmatrix_row_25_w_clkbuf_0[77]/Q[13] swmatrix_row_25_w_clkbuf_0[77]/Q[14] swmatrix_row_25_w_clkbuf_0[77]/Q[15]
+ swmatrix_row_25_w_clkbuf_0[77]/Q[16] swmatrix_row_25_w_clkbuf_0[77]/Q[17] swmatrix_row_25_w_clkbuf_0[77]/Q[18]
+ swmatrix_row_25_w_clkbuf_0[77]/Q[19] swmatrix_row_25_w_clkbuf_0[77]/Q[20] swmatrix_row_25_w_clkbuf_0[77]/Q[21]
+ swmatrix_row_25_w_clkbuf_0[77]/Q[22] swmatrix_row_25_w_clkbuf_0[77]/Q[23] swmatrix_row_25_w_clkbuf_0[77]/Q[24]
+ swmatrix_row_25_w_clkbuf_0[76]/D_in PIN[53] swmatrix_row_25_w_clkbuf_0[77]/Q[1]
+ swmatrix_row_25_w_clkbuf_0[77]/Q[2] swmatrix_row_25_w_clkbuf_0[77]/D_in PHI_1_in
+ BUS[20] swmatrix_row_25_w_clkbuf_0[77]/ShiftReg_row_25_0/DFF_2phase_1$1_0[23]/gf180mcu_fd_sc_mcu9t5v0__latq_1$2_1/Q
+ BUS[23] enable_in BUS[22] BUS[25] PHI_2_in BUS[8] BUS[11] BUS[2] BUS[18] VSSd BUS[14]
+ BUS[5] swmatrix_row_25_w_clkbuf
Xswmatrix_row_25_w_clkbuf_0[78] VDDd BUS[24] BUS[21] BUS[19] BUS[17] BUS[16] BUS[15]
+ BUS[13] BUS[12] BUS[10] BUS[9] BUS[7] BUS[6] BUS[4] BUS[3] BUS[1] swmatrix_row_25_w_clkbuf_0[78]/Q[3]
+ swmatrix_row_25_w_clkbuf_0[78]/Q[4] swmatrix_row_25_w_clkbuf_0[78]/Q[5] swmatrix_row_25_w_clkbuf_0[78]/Q[6]
+ swmatrix_row_25_w_clkbuf_0[78]/Q[7] swmatrix_row_25_w_clkbuf_0[78]/Q[8] swmatrix_row_25_w_clkbuf_0[78]/Q[9]
+ swmatrix_row_25_w_clkbuf_0[78]/Q[10] swmatrix_row_25_w_clkbuf_0[78]/Q[11] swmatrix_row_25_w_clkbuf_0[78]/Q[12]
+ swmatrix_row_25_w_clkbuf_0[78]/Q[13] swmatrix_row_25_w_clkbuf_0[78]/Q[14] swmatrix_row_25_w_clkbuf_0[78]/Q[15]
+ swmatrix_row_25_w_clkbuf_0[78]/Q[16] swmatrix_row_25_w_clkbuf_0[78]/Q[17] swmatrix_row_25_w_clkbuf_0[78]/Q[18]
+ swmatrix_row_25_w_clkbuf_0[78]/Q[19] swmatrix_row_25_w_clkbuf_0[78]/Q[20] swmatrix_row_25_w_clkbuf_0[78]/Q[21]
+ swmatrix_row_25_w_clkbuf_0[78]/Q[22] swmatrix_row_25_w_clkbuf_0[78]/Q[23] swmatrix_row_25_w_clkbuf_0[78]/Q[24]
+ swmatrix_row_25_w_clkbuf_0[77]/D_in PIN[52] swmatrix_row_25_w_clkbuf_0[78]/Q[1]
+ swmatrix_row_25_w_clkbuf_0[78]/Q[2] swmatrix_row_25_w_clkbuf_0[78]/D_in PHI_1_in
+ BUS[20] swmatrix_row_25_w_clkbuf_0[78]/ShiftReg_row_25_0/DFF_2phase_1$1_0[23]/gf180mcu_fd_sc_mcu9t5v0__latq_1$2_1/Q
+ BUS[23] enable_in BUS[22] BUS[25] PHI_2_in BUS[8] BUS[11] BUS[2] BUS[18] VSSd BUS[14]
+ BUS[5] swmatrix_row_25_w_clkbuf
Xswmatrix_row_25_w_clkbuf_0[79] VDDd BUS[24] BUS[21] BUS[19] BUS[17] BUS[16] BUS[15]
+ BUS[13] BUS[12] BUS[10] BUS[9] BUS[7] BUS[6] BUS[4] BUS[3] BUS[1] swmatrix_row_25_w_clkbuf_0[79]/Q[3]
+ swmatrix_row_25_w_clkbuf_0[79]/Q[4] swmatrix_row_25_w_clkbuf_0[79]/Q[5] swmatrix_row_25_w_clkbuf_0[79]/Q[6]
+ swmatrix_row_25_w_clkbuf_0[79]/Q[7] swmatrix_row_25_w_clkbuf_0[79]/Q[8] swmatrix_row_25_w_clkbuf_0[79]/Q[9]
+ swmatrix_row_25_w_clkbuf_0[79]/Q[10] swmatrix_row_25_w_clkbuf_0[79]/Q[11] swmatrix_row_25_w_clkbuf_0[79]/Q[12]
+ swmatrix_row_25_w_clkbuf_0[79]/Q[13] swmatrix_row_25_w_clkbuf_0[79]/Q[14] swmatrix_row_25_w_clkbuf_0[79]/Q[15]
+ swmatrix_row_25_w_clkbuf_0[79]/Q[16] swmatrix_row_25_w_clkbuf_0[79]/Q[17] swmatrix_row_25_w_clkbuf_0[79]/Q[18]
+ swmatrix_row_25_w_clkbuf_0[79]/Q[19] swmatrix_row_25_w_clkbuf_0[79]/Q[20] swmatrix_row_25_w_clkbuf_0[79]/Q[21]
+ swmatrix_row_25_w_clkbuf_0[79]/Q[22] swmatrix_row_25_w_clkbuf_0[79]/Q[23] swmatrix_row_25_w_clkbuf_0[79]/Q[24]
+ swmatrix_row_25_w_clkbuf_0[78]/D_in PIN[51] swmatrix_row_25_w_clkbuf_0[79]/Q[1]
+ swmatrix_row_25_w_clkbuf_0[79]/Q[2] swmatrix_row_25_w_clkbuf_0[79]/D_in PHI_1_in
+ BUS[20] swmatrix_row_25_w_clkbuf_0[79]/ShiftReg_row_25_0/DFF_2phase_1$1_0[23]/gf180mcu_fd_sc_mcu9t5v0__latq_1$2_1/Q
+ BUS[23] enable_in BUS[22] BUS[25] PHI_2_in BUS[8] BUS[11] BUS[2] BUS[18] VSSd BUS[14]
+ BUS[5] swmatrix_row_25_w_clkbuf
Xswmatrix_row_25_w_clkbuf_0[80] VDDd BUS[24] BUS[21] BUS[19] BUS[17] BUS[16] BUS[15]
+ BUS[13] BUS[12] BUS[10] BUS[9] BUS[7] BUS[6] BUS[4] BUS[3] BUS[1] swmatrix_row_25_w_clkbuf_0[80]/Q[3]
+ swmatrix_row_25_w_clkbuf_0[80]/Q[4] swmatrix_row_25_w_clkbuf_0[80]/Q[5] swmatrix_row_25_w_clkbuf_0[80]/Q[6]
+ swmatrix_row_25_w_clkbuf_0[80]/Q[7] swmatrix_row_25_w_clkbuf_0[80]/Q[8] swmatrix_row_25_w_clkbuf_0[80]/Q[9]
+ swmatrix_row_25_w_clkbuf_0[80]/Q[10] swmatrix_row_25_w_clkbuf_0[80]/Q[11] swmatrix_row_25_w_clkbuf_0[80]/Q[12]
+ swmatrix_row_25_w_clkbuf_0[80]/Q[13] swmatrix_row_25_w_clkbuf_0[80]/Q[14] swmatrix_row_25_w_clkbuf_0[80]/Q[15]
+ swmatrix_row_25_w_clkbuf_0[80]/Q[16] swmatrix_row_25_w_clkbuf_0[80]/Q[17] swmatrix_row_25_w_clkbuf_0[80]/Q[18]
+ swmatrix_row_25_w_clkbuf_0[80]/Q[19] swmatrix_row_25_w_clkbuf_0[80]/Q[20] swmatrix_row_25_w_clkbuf_0[80]/Q[21]
+ swmatrix_row_25_w_clkbuf_0[80]/Q[22] swmatrix_row_25_w_clkbuf_0[80]/Q[23] swmatrix_row_25_w_clkbuf_0[80]/Q[24]
+ swmatrix_row_25_w_clkbuf_0[79]/D_in PIN[50] swmatrix_row_25_w_clkbuf_0[80]/Q[1]
+ swmatrix_row_25_w_clkbuf_0[80]/Q[2] swmatrix_row_25_w_clkbuf_0[80]/D_in PHI_1_in
+ BUS[20] swmatrix_row_25_w_clkbuf_0[80]/ShiftReg_row_25_0/DFF_2phase_1$1_0[23]/gf180mcu_fd_sc_mcu9t5v0__latq_1$2_1/Q
+ BUS[23] enable_in BUS[22] BUS[25] PHI_2_in BUS[8] BUS[11] BUS[2] BUS[18] VSSd BUS[14]
+ BUS[5] swmatrix_row_25_w_clkbuf
Xswmatrix_row_25_w_clkbuf_0[81] VDDd BUS[24] BUS[21] BUS[19] BUS[17] BUS[16] BUS[15]
+ BUS[13] BUS[12] BUS[10] BUS[9] BUS[7] BUS[6] BUS[4] BUS[3] BUS[1] swmatrix_row_25_w_clkbuf_0[81]/Q[3]
+ swmatrix_row_25_w_clkbuf_0[81]/Q[4] swmatrix_row_25_w_clkbuf_0[81]/Q[5] swmatrix_row_25_w_clkbuf_0[81]/Q[6]
+ swmatrix_row_25_w_clkbuf_0[81]/Q[7] swmatrix_row_25_w_clkbuf_0[81]/Q[8] swmatrix_row_25_w_clkbuf_0[81]/Q[9]
+ swmatrix_row_25_w_clkbuf_0[81]/Q[10] swmatrix_row_25_w_clkbuf_0[81]/Q[11] swmatrix_row_25_w_clkbuf_0[81]/Q[12]
+ swmatrix_row_25_w_clkbuf_0[81]/Q[13] swmatrix_row_25_w_clkbuf_0[81]/Q[14] swmatrix_row_25_w_clkbuf_0[81]/Q[15]
+ swmatrix_row_25_w_clkbuf_0[81]/Q[16] swmatrix_row_25_w_clkbuf_0[81]/Q[17] swmatrix_row_25_w_clkbuf_0[81]/Q[18]
+ swmatrix_row_25_w_clkbuf_0[81]/Q[19] swmatrix_row_25_w_clkbuf_0[81]/Q[20] swmatrix_row_25_w_clkbuf_0[81]/Q[21]
+ swmatrix_row_25_w_clkbuf_0[81]/Q[22] swmatrix_row_25_w_clkbuf_0[81]/Q[23] swmatrix_row_25_w_clkbuf_0[81]/Q[24]
+ swmatrix_row_25_w_clkbuf_0[80]/D_in PIN[49] swmatrix_row_25_w_clkbuf_0[81]/Q[1]
+ swmatrix_row_25_w_clkbuf_0[81]/Q[2] swmatrix_row_25_w_clkbuf_0[81]/D_in PHI_1_in
+ BUS[20] swmatrix_row_25_w_clkbuf_0[81]/ShiftReg_row_25_0/DFF_2phase_1$1_0[23]/gf180mcu_fd_sc_mcu9t5v0__latq_1$2_1/Q
+ BUS[23] enable_in BUS[22] BUS[25] PHI_2_in BUS[8] BUS[11] BUS[2] BUS[18] VSSd BUS[14]
+ BUS[5] swmatrix_row_25_w_clkbuf
Xswmatrix_row_25_w_clkbuf_0[82] VDDd BUS[24] BUS[21] BUS[19] BUS[17] BUS[16] BUS[15]
+ BUS[13] BUS[12] BUS[10] BUS[9] BUS[7] BUS[6] BUS[4] BUS[3] BUS[1] swmatrix_row_25_w_clkbuf_0[82]/Q[3]
+ swmatrix_row_25_w_clkbuf_0[82]/Q[4] swmatrix_row_25_w_clkbuf_0[82]/Q[5] swmatrix_row_25_w_clkbuf_0[82]/Q[6]
+ swmatrix_row_25_w_clkbuf_0[82]/Q[7] swmatrix_row_25_w_clkbuf_0[82]/Q[8] swmatrix_row_25_w_clkbuf_0[82]/Q[9]
+ swmatrix_row_25_w_clkbuf_0[82]/Q[10] swmatrix_row_25_w_clkbuf_0[82]/Q[11] swmatrix_row_25_w_clkbuf_0[82]/Q[12]
+ swmatrix_row_25_w_clkbuf_0[82]/Q[13] swmatrix_row_25_w_clkbuf_0[82]/Q[14] swmatrix_row_25_w_clkbuf_0[82]/Q[15]
+ swmatrix_row_25_w_clkbuf_0[82]/Q[16] swmatrix_row_25_w_clkbuf_0[82]/Q[17] swmatrix_row_25_w_clkbuf_0[82]/Q[18]
+ swmatrix_row_25_w_clkbuf_0[82]/Q[19] swmatrix_row_25_w_clkbuf_0[82]/Q[20] swmatrix_row_25_w_clkbuf_0[82]/Q[21]
+ swmatrix_row_25_w_clkbuf_0[82]/Q[22] swmatrix_row_25_w_clkbuf_0[82]/Q[23] swmatrix_row_25_w_clkbuf_0[82]/Q[24]
+ swmatrix_row_25_w_clkbuf_0[81]/D_in PIN[48] swmatrix_row_25_w_clkbuf_0[82]/Q[1]
+ swmatrix_row_25_w_clkbuf_0[82]/Q[2] swmatrix_row_25_w_clkbuf_0[82]/D_in PHI_1_in
+ BUS[20] swmatrix_row_25_w_clkbuf_0[82]/ShiftReg_row_25_0/DFF_2phase_1$1_0[23]/gf180mcu_fd_sc_mcu9t5v0__latq_1$2_1/Q
+ BUS[23] enable_in BUS[22] BUS[25] PHI_2_in BUS[8] BUS[11] BUS[2] BUS[18] VSSd BUS[14]
+ BUS[5] swmatrix_row_25_w_clkbuf
Xswmatrix_row_25_w_clkbuf_0[83] VDDd BUS[24] BUS[21] BUS[19] BUS[17] BUS[16] BUS[15]
+ BUS[13] BUS[12] BUS[10] BUS[9] BUS[7] BUS[6] BUS[4] BUS[3] BUS[1] swmatrix_row_25_w_clkbuf_0[83]/Q[3]
+ swmatrix_row_25_w_clkbuf_0[83]/Q[4] swmatrix_row_25_w_clkbuf_0[83]/Q[5] swmatrix_row_25_w_clkbuf_0[83]/Q[6]
+ swmatrix_row_25_w_clkbuf_0[83]/Q[7] swmatrix_row_25_w_clkbuf_0[83]/Q[8] swmatrix_row_25_w_clkbuf_0[83]/Q[9]
+ swmatrix_row_25_w_clkbuf_0[83]/Q[10] swmatrix_row_25_w_clkbuf_0[83]/Q[11] swmatrix_row_25_w_clkbuf_0[83]/Q[12]
+ swmatrix_row_25_w_clkbuf_0[83]/Q[13] swmatrix_row_25_w_clkbuf_0[83]/Q[14] swmatrix_row_25_w_clkbuf_0[83]/Q[15]
+ swmatrix_row_25_w_clkbuf_0[83]/Q[16] swmatrix_row_25_w_clkbuf_0[83]/Q[17] swmatrix_row_25_w_clkbuf_0[83]/Q[18]
+ swmatrix_row_25_w_clkbuf_0[83]/Q[19] swmatrix_row_25_w_clkbuf_0[83]/Q[20] swmatrix_row_25_w_clkbuf_0[83]/Q[21]
+ swmatrix_row_25_w_clkbuf_0[83]/Q[22] swmatrix_row_25_w_clkbuf_0[83]/Q[23] swmatrix_row_25_w_clkbuf_0[83]/Q[24]
+ swmatrix_row_25_w_clkbuf_0[82]/D_in PIN[47] swmatrix_row_25_w_clkbuf_0[83]/Q[1]
+ swmatrix_row_25_w_clkbuf_0[83]/Q[2] swmatrix_row_25_w_clkbuf_0[83]/D_in PHI_1_in
+ BUS[20] swmatrix_row_25_w_clkbuf_0[83]/ShiftReg_row_25_0/DFF_2phase_1$1_0[23]/gf180mcu_fd_sc_mcu9t5v0__latq_1$2_1/Q
+ BUS[23] enable_in BUS[22] BUS[25] PHI_2_in BUS[8] BUS[11] BUS[2] BUS[18] VSSd BUS[14]
+ BUS[5] swmatrix_row_25_w_clkbuf
Xswmatrix_row_25_w_clkbuf_0[84] VDDd BUS[24] BUS[21] BUS[19] BUS[17] BUS[16] BUS[15]
+ BUS[13] BUS[12] BUS[10] BUS[9] BUS[7] BUS[6] BUS[4] BUS[3] BUS[1] swmatrix_row_25_w_clkbuf_0[84]/Q[3]
+ swmatrix_row_25_w_clkbuf_0[84]/Q[4] swmatrix_row_25_w_clkbuf_0[84]/Q[5] swmatrix_row_25_w_clkbuf_0[84]/Q[6]
+ swmatrix_row_25_w_clkbuf_0[84]/Q[7] swmatrix_row_25_w_clkbuf_0[84]/Q[8] swmatrix_row_25_w_clkbuf_0[84]/Q[9]
+ swmatrix_row_25_w_clkbuf_0[84]/Q[10] swmatrix_row_25_w_clkbuf_0[84]/Q[11] swmatrix_row_25_w_clkbuf_0[84]/Q[12]
+ swmatrix_row_25_w_clkbuf_0[84]/Q[13] swmatrix_row_25_w_clkbuf_0[84]/Q[14] swmatrix_row_25_w_clkbuf_0[84]/Q[15]
+ swmatrix_row_25_w_clkbuf_0[84]/Q[16] swmatrix_row_25_w_clkbuf_0[84]/Q[17] swmatrix_row_25_w_clkbuf_0[84]/Q[18]
+ swmatrix_row_25_w_clkbuf_0[84]/Q[19] swmatrix_row_25_w_clkbuf_0[84]/Q[20] swmatrix_row_25_w_clkbuf_0[84]/Q[21]
+ swmatrix_row_25_w_clkbuf_0[84]/Q[22] swmatrix_row_25_w_clkbuf_0[84]/Q[23] swmatrix_row_25_w_clkbuf_0[84]/Q[24]
+ swmatrix_row_25_w_clkbuf_0[83]/D_in PIN[46] swmatrix_row_25_w_clkbuf_0[84]/Q[1]
+ swmatrix_row_25_w_clkbuf_0[84]/Q[2] swmatrix_row_25_w_clkbuf_0[84]/D_in PHI_1_in
+ BUS[20] swmatrix_row_25_w_clkbuf_0[84]/ShiftReg_row_25_0/DFF_2phase_1$1_0[23]/gf180mcu_fd_sc_mcu9t5v0__latq_1$2_1/Q
+ BUS[23] enable_in BUS[22] BUS[25] PHI_2_in BUS[8] BUS[11] BUS[2] BUS[18] VSSd BUS[14]
+ BUS[5] swmatrix_row_25_w_clkbuf
Xswmatrix_row_25_w_clkbuf_0[85] VDDd BUS[24] BUS[21] BUS[19] BUS[17] BUS[16] BUS[15]
+ BUS[13] BUS[12] BUS[10] BUS[9] BUS[7] BUS[6] BUS[4] BUS[3] BUS[1] swmatrix_row_25_w_clkbuf_0[85]/Q[3]
+ swmatrix_row_25_w_clkbuf_0[85]/Q[4] swmatrix_row_25_w_clkbuf_0[85]/Q[5] swmatrix_row_25_w_clkbuf_0[85]/Q[6]
+ swmatrix_row_25_w_clkbuf_0[85]/Q[7] swmatrix_row_25_w_clkbuf_0[85]/Q[8] swmatrix_row_25_w_clkbuf_0[85]/Q[9]
+ swmatrix_row_25_w_clkbuf_0[85]/Q[10] swmatrix_row_25_w_clkbuf_0[85]/Q[11] swmatrix_row_25_w_clkbuf_0[85]/Q[12]
+ swmatrix_row_25_w_clkbuf_0[85]/Q[13] swmatrix_row_25_w_clkbuf_0[85]/Q[14] swmatrix_row_25_w_clkbuf_0[85]/Q[15]
+ swmatrix_row_25_w_clkbuf_0[85]/Q[16] swmatrix_row_25_w_clkbuf_0[85]/Q[17] swmatrix_row_25_w_clkbuf_0[85]/Q[18]
+ swmatrix_row_25_w_clkbuf_0[85]/Q[19] swmatrix_row_25_w_clkbuf_0[85]/Q[20] swmatrix_row_25_w_clkbuf_0[85]/Q[21]
+ swmatrix_row_25_w_clkbuf_0[85]/Q[22] swmatrix_row_25_w_clkbuf_0[85]/Q[23] swmatrix_row_25_w_clkbuf_0[85]/Q[24]
+ swmatrix_row_25_w_clkbuf_0[84]/D_in PIN[45] swmatrix_row_25_w_clkbuf_0[85]/Q[1]
+ swmatrix_row_25_w_clkbuf_0[85]/Q[2] swmatrix_row_25_w_clkbuf_0[85]/D_in PHI_1_in
+ BUS[20] swmatrix_row_25_w_clkbuf_0[85]/ShiftReg_row_25_0/DFF_2phase_1$1_0[23]/gf180mcu_fd_sc_mcu9t5v0__latq_1$2_1/Q
+ BUS[23] enable_in BUS[22] BUS[25] PHI_2_in BUS[8] BUS[11] BUS[2] BUS[18] VSSd BUS[14]
+ BUS[5] swmatrix_row_25_w_clkbuf
Xswmatrix_row_25_w_clkbuf_0[86] VDDd BUS[24] BUS[21] BUS[19] BUS[17] BUS[16] BUS[15]
+ BUS[13] BUS[12] BUS[10] BUS[9] BUS[7] BUS[6] BUS[4] BUS[3] BUS[1] swmatrix_row_25_w_clkbuf_0[86]/Q[3]
+ swmatrix_row_25_w_clkbuf_0[86]/Q[4] swmatrix_row_25_w_clkbuf_0[86]/Q[5] swmatrix_row_25_w_clkbuf_0[86]/Q[6]
+ swmatrix_row_25_w_clkbuf_0[86]/Q[7] swmatrix_row_25_w_clkbuf_0[86]/Q[8] swmatrix_row_25_w_clkbuf_0[86]/Q[9]
+ swmatrix_row_25_w_clkbuf_0[86]/Q[10] swmatrix_row_25_w_clkbuf_0[86]/Q[11] swmatrix_row_25_w_clkbuf_0[86]/Q[12]
+ swmatrix_row_25_w_clkbuf_0[86]/Q[13] swmatrix_row_25_w_clkbuf_0[86]/Q[14] swmatrix_row_25_w_clkbuf_0[86]/Q[15]
+ swmatrix_row_25_w_clkbuf_0[86]/Q[16] swmatrix_row_25_w_clkbuf_0[86]/Q[17] swmatrix_row_25_w_clkbuf_0[86]/Q[18]
+ swmatrix_row_25_w_clkbuf_0[86]/Q[19] swmatrix_row_25_w_clkbuf_0[86]/Q[20] swmatrix_row_25_w_clkbuf_0[86]/Q[21]
+ swmatrix_row_25_w_clkbuf_0[86]/Q[22] swmatrix_row_25_w_clkbuf_0[86]/Q[23] swmatrix_row_25_w_clkbuf_0[86]/Q[24]
+ swmatrix_row_25_w_clkbuf_0[85]/D_in PIN[44] swmatrix_row_25_w_clkbuf_0[86]/Q[1]
+ swmatrix_row_25_w_clkbuf_0[86]/Q[2] swmatrix_row_25_w_clkbuf_0[86]/D_in PHI_1_in
+ BUS[20] swmatrix_row_25_w_clkbuf_0[86]/ShiftReg_row_25_0/DFF_2phase_1$1_0[23]/gf180mcu_fd_sc_mcu9t5v0__latq_1$2_1/Q
+ BUS[23] enable_in BUS[22] BUS[25] PHI_2_in BUS[8] BUS[11] BUS[2] BUS[18] VSSd BUS[14]
+ BUS[5] swmatrix_row_25_w_clkbuf
Xswmatrix_row_25_w_clkbuf_0[87] VDDd BUS[24] BUS[21] BUS[19] BUS[17] BUS[16] BUS[15]
+ BUS[13] BUS[12] BUS[10] BUS[9] BUS[7] BUS[6] BUS[4] BUS[3] BUS[1] swmatrix_row_25_w_clkbuf_0[87]/Q[3]
+ swmatrix_row_25_w_clkbuf_0[87]/Q[4] swmatrix_row_25_w_clkbuf_0[87]/Q[5] swmatrix_row_25_w_clkbuf_0[87]/Q[6]
+ swmatrix_row_25_w_clkbuf_0[87]/Q[7] swmatrix_row_25_w_clkbuf_0[87]/Q[8] swmatrix_row_25_w_clkbuf_0[87]/Q[9]
+ swmatrix_row_25_w_clkbuf_0[87]/Q[10] swmatrix_row_25_w_clkbuf_0[87]/Q[11] swmatrix_row_25_w_clkbuf_0[87]/Q[12]
+ swmatrix_row_25_w_clkbuf_0[87]/Q[13] swmatrix_row_25_w_clkbuf_0[87]/Q[14] swmatrix_row_25_w_clkbuf_0[87]/Q[15]
+ swmatrix_row_25_w_clkbuf_0[87]/Q[16] swmatrix_row_25_w_clkbuf_0[87]/Q[17] swmatrix_row_25_w_clkbuf_0[87]/Q[18]
+ swmatrix_row_25_w_clkbuf_0[87]/Q[19] swmatrix_row_25_w_clkbuf_0[87]/Q[20] swmatrix_row_25_w_clkbuf_0[87]/Q[21]
+ swmatrix_row_25_w_clkbuf_0[87]/Q[22] swmatrix_row_25_w_clkbuf_0[87]/Q[23] swmatrix_row_25_w_clkbuf_0[87]/Q[24]
+ swmatrix_row_25_w_clkbuf_0[86]/D_in PIN[43] swmatrix_row_25_w_clkbuf_0[87]/Q[1]
+ swmatrix_row_25_w_clkbuf_0[87]/Q[2] swmatrix_row_25_w_clkbuf_0[87]/D_in PHI_1_in
+ BUS[20] swmatrix_row_25_w_clkbuf_0[87]/ShiftReg_row_25_0/DFF_2phase_1$1_0[23]/gf180mcu_fd_sc_mcu9t5v0__latq_1$2_1/Q
+ BUS[23] enable_in BUS[22] BUS[25] PHI_2_in BUS[8] BUS[11] BUS[2] BUS[18] VSSd BUS[14]
+ BUS[5] swmatrix_row_25_w_clkbuf
Xswmatrix_row_25_w_clkbuf_0[88] VDDd BUS[24] BUS[21] BUS[19] BUS[17] BUS[16] BUS[15]
+ BUS[13] BUS[12] BUS[10] BUS[9] BUS[7] BUS[6] BUS[4] BUS[3] BUS[1] swmatrix_row_25_w_clkbuf_0[88]/Q[3]
+ swmatrix_row_25_w_clkbuf_0[88]/Q[4] swmatrix_row_25_w_clkbuf_0[88]/Q[5] swmatrix_row_25_w_clkbuf_0[88]/Q[6]
+ swmatrix_row_25_w_clkbuf_0[88]/Q[7] swmatrix_row_25_w_clkbuf_0[88]/Q[8] swmatrix_row_25_w_clkbuf_0[88]/Q[9]
+ swmatrix_row_25_w_clkbuf_0[88]/Q[10] swmatrix_row_25_w_clkbuf_0[88]/Q[11] swmatrix_row_25_w_clkbuf_0[88]/Q[12]
+ swmatrix_row_25_w_clkbuf_0[88]/Q[13] swmatrix_row_25_w_clkbuf_0[88]/Q[14] swmatrix_row_25_w_clkbuf_0[88]/Q[15]
+ swmatrix_row_25_w_clkbuf_0[88]/Q[16] swmatrix_row_25_w_clkbuf_0[88]/Q[17] swmatrix_row_25_w_clkbuf_0[88]/Q[18]
+ swmatrix_row_25_w_clkbuf_0[88]/Q[19] swmatrix_row_25_w_clkbuf_0[88]/Q[20] swmatrix_row_25_w_clkbuf_0[88]/Q[21]
+ swmatrix_row_25_w_clkbuf_0[88]/Q[22] swmatrix_row_25_w_clkbuf_0[88]/Q[23] swmatrix_row_25_w_clkbuf_0[88]/Q[24]
+ swmatrix_row_25_w_clkbuf_0[87]/D_in PIN[42] swmatrix_row_25_w_clkbuf_0[88]/Q[1]
+ swmatrix_row_25_w_clkbuf_0[88]/Q[2] swmatrix_row_25_w_clkbuf_0[88]/D_in PHI_1_in
+ BUS[20] swmatrix_row_25_w_clkbuf_0[88]/ShiftReg_row_25_0/DFF_2phase_1$1_0[23]/gf180mcu_fd_sc_mcu9t5v0__latq_1$2_1/Q
+ BUS[23] enable_in BUS[22] BUS[25] PHI_2_in BUS[8] BUS[11] BUS[2] BUS[18] VSSd BUS[14]
+ BUS[5] swmatrix_row_25_w_clkbuf
Xswmatrix_row_25_w_clkbuf_0[89] VDDd BUS[24] BUS[21] BUS[19] BUS[17] BUS[16] BUS[15]
+ BUS[13] BUS[12] BUS[10] BUS[9] BUS[7] BUS[6] BUS[4] BUS[3] BUS[1] swmatrix_row_25_w_clkbuf_0[89]/Q[3]
+ swmatrix_row_25_w_clkbuf_0[89]/Q[4] swmatrix_row_25_w_clkbuf_0[89]/Q[5] swmatrix_row_25_w_clkbuf_0[89]/Q[6]
+ swmatrix_row_25_w_clkbuf_0[89]/Q[7] swmatrix_row_25_w_clkbuf_0[89]/Q[8] swmatrix_row_25_w_clkbuf_0[89]/Q[9]
+ swmatrix_row_25_w_clkbuf_0[89]/Q[10] swmatrix_row_25_w_clkbuf_0[89]/Q[11] swmatrix_row_25_w_clkbuf_0[89]/Q[12]
+ swmatrix_row_25_w_clkbuf_0[89]/Q[13] swmatrix_row_25_w_clkbuf_0[89]/Q[14] swmatrix_row_25_w_clkbuf_0[89]/Q[15]
+ swmatrix_row_25_w_clkbuf_0[89]/Q[16] swmatrix_row_25_w_clkbuf_0[89]/Q[17] swmatrix_row_25_w_clkbuf_0[89]/Q[18]
+ swmatrix_row_25_w_clkbuf_0[89]/Q[19] swmatrix_row_25_w_clkbuf_0[89]/Q[20] swmatrix_row_25_w_clkbuf_0[89]/Q[21]
+ swmatrix_row_25_w_clkbuf_0[89]/Q[22] swmatrix_row_25_w_clkbuf_0[89]/Q[23] swmatrix_row_25_w_clkbuf_0[89]/Q[24]
+ swmatrix_row_25_w_clkbuf_0[88]/D_in PIN[41] swmatrix_row_25_w_clkbuf_0[89]/Q[1]
+ swmatrix_row_25_w_clkbuf_0[89]/Q[2] swmatrix_row_25_w_clkbuf_0[89]/D_in PHI_1_in
+ BUS[20] swmatrix_row_25_w_clkbuf_0[89]/ShiftReg_row_25_0/DFF_2phase_1$1_0[23]/gf180mcu_fd_sc_mcu9t5v0__latq_1$2_1/Q
+ BUS[23] enable_in BUS[22] BUS[25] PHI_2_in BUS[8] BUS[11] BUS[2] BUS[18] VSSd BUS[14]
+ BUS[5] swmatrix_row_25_w_clkbuf
Xswmatrix_row_25_w_clkbuf_0[90] VDDd BUS[24] BUS[21] BUS[19] BUS[17] BUS[16] BUS[15]
+ BUS[13] BUS[12] BUS[10] BUS[9] BUS[7] BUS[6] BUS[4] BUS[3] BUS[1] swmatrix_row_25_w_clkbuf_0[90]/Q[3]
+ swmatrix_row_25_w_clkbuf_0[90]/Q[4] swmatrix_row_25_w_clkbuf_0[90]/Q[5] swmatrix_row_25_w_clkbuf_0[90]/Q[6]
+ swmatrix_row_25_w_clkbuf_0[90]/Q[7] swmatrix_row_25_w_clkbuf_0[90]/Q[8] swmatrix_row_25_w_clkbuf_0[90]/Q[9]
+ swmatrix_row_25_w_clkbuf_0[90]/Q[10] swmatrix_row_25_w_clkbuf_0[90]/Q[11] swmatrix_row_25_w_clkbuf_0[90]/Q[12]
+ swmatrix_row_25_w_clkbuf_0[90]/Q[13] swmatrix_row_25_w_clkbuf_0[90]/Q[14] swmatrix_row_25_w_clkbuf_0[90]/Q[15]
+ swmatrix_row_25_w_clkbuf_0[90]/Q[16] swmatrix_row_25_w_clkbuf_0[90]/Q[17] swmatrix_row_25_w_clkbuf_0[90]/Q[18]
+ swmatrix_row_25_w_clkbuf_0[90]/Q[19] swmatrix_row_25_w_clkbuf_0[90]/Q[20] swmatrix_row_25_w_clkbuf_0[90]/Q[21]
+ swmatrix_row_25_w_clkbuf_0[90]/Q[22] swmatrix_row_25_w_clkbuf_0[90]/Q[23] swmatrix_row_25_w_clkbuf_0[90]/Q[24]
+ swmatrix_row_25_w_clkbuf_0[89]/D_in PIN[40] swmatrix_row_25_w_clkbuf_0[90]/Q[1]
+ swmatrix_row_25_w_clkbuf_0[90]/Q[2] swmatrix_row_25_w_clkbuf_0[90]/D_in PHI_1_in
+ BUS[20] swmatrix_row_25_w_clkbuf_0[90]/ShiftReg_row_25_0/DFF_2phase_1$1_0[23]/gf180mcu_fd_sc_mcu9t5v0__latq_1$2_1/Q
+ BUS[23] enable_in BUS[22] BUS[25] PHI_2_in BUS[8] BUS[11] BUS[2] BUS[18] VSSd BUS[14]
+ BUS[5] swmatrix_row_25_w_clkbuf
Xswmatrix_row_25_w_clkbuf_0[91] VDDd BUS[24] BUS[21] BUS[19] BUS[17] BUS[16] BUS[15]
+ BUS[13] BUS[12] BUS[10] BUS[9] BUS[7] BUS[6] BUS[4] BUS[3] BUS[1] swmatrix_row_25_w_clkbuf_0[91]/Q[3]
+ swmatrix_row_25_w_clkbuf_0[91]/Q[4] swmatrix_row_25_w_clkbuf_0[91]/Q[5] swmatrix_row_25_w_clkbuf_0[91]/Q[6]
+ swmatrix_row_25_w_clkbuf_0[91]/Q[7] swmatrix_row_25_w_clkbuf_0[91]/Q[8] swmatrix_row_25_w_clkbuf_0[91]/Q[9]
+ swmatrix_row_25_w_clkbuf_0[91]/Q[10] swmatrix_row_25_w_clkbuf_0[91]/Q[11] swmatrix_row_25_w_clkbuf_0[91]/Q[12]
+ swmatrix_row_25_w_clkbuf_0[91]/Q[13] swmatrix_row_25_w_clkbuf_0[91]/Q[14] swmatrix_row_25_w_clkbuf_0[91]/Q[15]
+ swmatrix_row_25_w_clkbuf_0[91]/Q[16] swmatrix_row_25_w_clkbuf_0[91]/Q[17] swmatrix_row_25_w_clkbuf_0[91]/Q[18]
+ swmatrix_row_25_w_clkbuf_0[91]/Q[19] swmatrix_row_25_w_clkbuf_0[91]/Q[20] swmatrix_row_25_w_clkbuf_0[91]/Q[21]
+ swmatrix_row_25_w_clkbuf_0[91]/Q[22] swmatrix_row_25_w_clkbuf_0[91]/Q[23] swmatrix_row_25_w_clkbuf_0[91]/Q[24]
+ swmatrix_row_25_w_clkbuf_0[90]/D_in PIN[39] swmatrix_row_25_w_clkbuf_0[91]/Q[1]
+ swmatrix_row_25_w_clkbuf_0[91]/Q[2] swmatrix_row_25_w_clkbuf_0[91]/D_in PHI_1_in
+ BUS[20] swmatrix_row_25_w_clkbuf_0[91]/ShiftReg_row_25_0/DFF_2phase_1$1_0[23]/gf180mcu_fd_sc_mcu9t5v0__latq_1$2_1/Q
+ BUS[23] enable_in BUS[22] BUS[25] PHI_2_in BUS[8] BUS[11] BUS[2] BUS[18] VSSd BUS[14]
+ BUS[5] swmatrix_row_25_w_clkbuf
Xswmatrix_row_25_w_clkbuf_0[92] VDDd BUS[24] BUS[21] BUS[19] BUS[17] BUS[16] BUS[15]
+ BUS[13] BUS[12] BUS[10] BUS[9] BUS[7] BUS[6] BUS[4] BUS[3] BUS[1] swmatrix_row_25_w_clkbuf_0[92]/Q[3]
+ swmatrix_row_25_w_clkbuf_0[92]/Q[4] swmatrix_row_25_w_clkbuf_0[92]/Q[5] swmatrix_row_25_w_clkbuf_0[92]/Q[6]
+ swmatrix_row_25_w_clkbuf_0[92]/Q[7] swmatrix_row_25_w_clkbuf_0[92]/Q[8] swmatrix_row_25_w_clkbuf_0[92]/Q[9]
+ swmatrix_row_25_w_clkbuf_0[92]/Q[10] swmatrix_row_25_w_clkbuf_0[92]/Q[11] swmatrix_row_25_w_clkbuf_0[92]/Q[12]
+ swmatrix_row_25_w_clkbuf_0[92]/Q[13] swmatrix_row_25_w_clkbuf_0[92]/Q[14] swmatrix_row_25_w_clkbuf_0[92]/Q[15]
+ swmatrix_row_25_w_clkbuf_0[92]/Q[16] swmatrix_row_25_w_clkbuf_0[92]/Q[17] swmatrix_row_25_w_clkbuf_0[92]/Q[18]
+ swmatrix_row_25_w_clkbuf_0[92]/Q[19] swmatrix_row_25_w_clkbuf_0[92]/Q[20] swmatrix_row_25_w_clkbuf_0[92]/Q[21]
+ swmatrix_row_25_w_clkbuf_0[92]/Q[22] swmatrix_row_25_w_clkbuf_0[92]/Q[23] swmatrix_row_25_w_clkbuf_0[92]/Q[24]
+ swmatrix_row_25_w_clkbuf_0[91]/D_in PIN[38] swmatrix_row_25_w_clkbuf_0[92]/Q[1]
+ swmatrix_row_25_w_clkbuf_0[92]/Q[2] swmatrix_row_25_w_clkbuf_0[92]/D_in PHI_1_in
+ BUS[20] swmatrix_row_25_w_clkbuf_0[92]/ShiftReg_row_25_0/DFF_2phase_1$1_0[23]/gf180mcu_fd_sc_mcu9t5v0__latq_1$2_1/Q
+ BUS[23] enable_in BUS[22] BUS[25] PHI_2_in BUS[8] BUS[11] BUS[2] BUS[18] VSSd BUS[14]
+ BUS[5] swmatrix_row_25_w_clkbuf
Xswmatrix_row_25_w_clkbuf_0[93] VDDd BUS[24] BUS[21] BUS[19] BUS[17] BUS[16] BUS[15]
+ BUS[13] BUS[12] BUS[10] BUS[9] BUS[7] BUS[6] BUS[4] BUS[3] BUS[1] swmatrix_row_25_w_clkbuf_0[93]/Q[3]
+ swmatrix_row_25_w_clkbuf_0[93]/Q[4] swmatrix_row_25_w_clkbuf_0[93]/Q[5] swmatrix_row_25_w_clkbuf_0[93]/Q[6]
+ swmatrix_row_25_w_clkbuf_0[93]/Q[7] swmatrix_row_25_w_clkbuf_0[93]/Q[8] swmatrix_row_25_w_clkbuf_0[93]/Q[9]
+ swmatrix_row_25_w_clkbuf_0[93]/Q[10] swmatrix_row_25_w_clkbuf_0[93]/Q[11] swmatrix_row_25_w_clkbuf_0[93]/Q[12]
+ swmatrix_row_25_w_clkbuf_0[93]/Q[13] swmatrix_row_25_w_clkbuf_0[93]/Q[14] swmatrix_row_25_w_clkbuf_0[93]/Q[15]
+ swmatrix_row_25_w_clkbuf_0[93]/Q[16] swmatrix_row_25_w_clkbuf_0[93]/Q[17] swmatrix_row_25_w_clkbuf_0[93]/Q[18]
+ swmatrix_row_25_w_clkbuf_0[93]/Q[19] swmatrix_row_25_w_clkbuf_0[93]/Q[20] swmatrix_row_25_w_clkbuf_0[93]/Q[21]
+ swmatrix_row_25_w_clkbuf_0[93]/Q[22] swmatrix_row_25_w_clkbuf_0[93]/Q[23] swmatrix_row_25_w_clkbuf_0[93]/Q[24]
+ swmatrix_row_25_w_clkbuf_0[92]/D_in PIN[37] swmatrix_row_25_w_clkbuf_0[93]/Q[1]
+ swmatrix_row_25_w_clkbuf_0[93]/Q[2] swmatrix_row_25_w_clkbuf_0[93]/D_in PHI_1_in
+ BUS[20] swmatrix_row_25_w_clkbuf_0[93]/ShiftReg_row_25_0/DFF_2phase_1$1_0[23]/gf180mcu_fd_sc_mcu9t5v0__latq_1$2_1/Q
+ BUS[23] enable_in BUS[22] BUS[25] PHI_2_in BUS[8] BUS[11] BUS[2] BUS[18] VSSd BUS[14]
+ BUS[5] swmatrix_row_25_w_clkbuf
Xswmatrix_row_25_w_clkbuf_0[94] VDDd BUS[24] BUS[21] BUS[19] BUS[17] BUS[16] BUS[15]
+ BUS[13] BUS[12] BUS[10] BUS[9] BUS[7] BUS[6] BUS[4] BUS[3] BUS[1] swmatrix_row_25_w_clkbuf_0[94]/Q[3]
+ swmatrix_row_25_w_clkbuf_0[94]/Q[4] swmatrix_row_25_w_clkbuf_0[94]/Q[5] swmatrix_row_25_w_clkbuf_0[94]/Q[6]
+ swmatrix_row_25_w_clkbuf_0[94]/Q[7] swmatrix_row_25_w_clkbuf_0[94]/Q[8] swmatrix_row_25_w_clkbuf_0[94]/Q[9]
+ swmatrix_row_25_w_clkbuf_0[94]/Q[10] swmatrix_row_25_w_clkbuf_0[94]/Q[11] swmatrix_row_25_w_clkbuf_0[94]/Q[12]
+ swmatrix_row_25_w_clkbuf_0[94]/Q[13] swmatrix_row_25_w_clkbuf_0[94]/Q[14] swmatrix_row_25_w_clkbuf_0[94]/Q[15]
+ swmatrix_row_25_w_clkbuf_0[94]/Q[16] swmatrix_row_25_w_clkbuf_0[94]/Q[17] swmatrix_row_25_w_clkbuf_0[94]/Q[18]
+ swmatrix_row_25_w_clkbuf_0[94]/Q[19] swmatrix_row_25_w_clkbuf_0[94]/Q[20] swmatrix_row_25_w_clkbuf_0[94]/Q[21]
+ swmatrix_row_25_w_clkbuf_0[94]/Q[22] swmatrix_row_25_w_clkbuf_0[94]/Q[23] swmatrix_row_25_w_clkbuf_0[94]/Q[24]
+ swmatrix_row_25_w_clkbuf_0[93]/D_in PIN[36] swmatrix_row_25_w_clkbuf_0[94]/Q[1]
+ swmatrix_row_25_w_clkbuf_0[94]/Q[2] swmatrix_row_25_w_clkbuf_0[94]/D_in PHI_1_in
+ BUS[20] swmatrix_row_25_w_clkbuf_0[94]/ShiftReg_row_25_0/DFF_2phase_1$1_0[23]/gf180mcu_fd_sc_mcu9t5v0__latq_1$2_1/Q
+ BUS[23] enable_in BUS[22] BUS[25] PHI_2_in BUS[8] BUS[11] BUS[2] BUS[18] VSSd BUS[14]
+ BUS[5] swmatrix_row_25_w_clkbuf
Xswmatrix_row_25_w_clkbuf_0[95] VDDd BUS[24] BUS[21] BUS[19] BUS[17] BUS[16] BUS[15]
+ BUS[13] BUS[12] BUS[10] BUS[9] BUS[7] BUS[6] BUS[4] BUS[3] BUS[1] swmatrix_row_25_w_clkbuf_0[95]/Q[3]
+ swmatrix_row_25_w_clkbuf_0[95]/Q[4] swmatrix_row_25_w_clkbuf_0[95]/Q[5] swmatrix_row_25_w_clkbuf_0[95]/Q[6]
+ swmatrix_row_25_w_clkbuf_0[95]/Q[7] swmatrix_row_25_w_clkbuf_0[95]/Q[8] swmatrix_row_25_w_clkbuf_0[95]/Q[9]
+ swmatrix_row_25_w_clkbuf_0[95]/Q[10] swmatrix_row_25_w_clkbuf_0[95]/Q[11] swmatrix_row_25_w_clkbuf_0[95]/Q[12]
+ swmatrix_row_25_w_clkbuf_0[95]/Q[13] swmatrix_row_25_w_clkbuf_0[95]/Q[14] swmatrix_row_25_w_clkbuf_0[95]/Q[15]
+ swmatrix_row_25_w_clkbuf_0[95]/Q[16] swmatrix_row_25_w_clkbuf_0[95]/Q[17] swmatrix_row_25_w_clkbuf_0[95]/Q[18]
+ swmatrix_row_25_w_clkbuf_0[95]/Q[19] swmatrix_row_25_w_clkbuf_0[95]/Q[20] swmatrix_row_25_w_clkbuf_0[95]/Q[21]
+ swmatrix_row_25_w_clkbuf_0[95]/Q[22] swmatrix_row_25_w_clkbuf_0[95]/Q[23] swmatrix_row_25_w_clkbuf_0[95]/Q[24]
+ swmatrix_row_25_w_clkbuf_0[94]/D_in PIN[35] swmatrix_row_25_w_clkbuf_0[95]/Q[1]
+ swmatrix_row_25_w_clkbuf_0[95]/Q[2] swmatrix_row_25_w_clkbuf_0[95]/D_in PHI_1_in
+ BUS[20] swmatrix_row_25_w_clkbuf_0[95]/ShiftReg_row_25_0/DFF_2phase_1$1_0[23]/gf180mcu_fd_sc_mcu9t5v0__latq_1$2_1/Q
+ BUS[23] enable_in BUS[22] BUS[25] PHI_2_in BUS[8] BUS[11] BUS[2] BUS[18] VSSd BUS[14]
+ BUS[5] swmatrix_row_25_w_clkbuf
Xswmatrix_row_25_w_clkbuf_0[96] VDDd BUS[24] BUS[21] BUS[19] BUS[17] BUS[16] BUS[15]
+ BUS[13] BUS[12] BUS[10] BUS[9] BUS[7] BUS[6] BUS[4] BUS[3] BUS[1] swmatrix_row_25_w_clkbuf_0[96]/Q[3]
+ swmatrix_row_25_w_clkbuf_0[96]/Q[4] swmatrix_row_25_w_clkbuf_0[96]/Q[5] swmatrix_row_25_w_clkbuf_0[96]/Q[6]
+ swmatrix_row_25_w_clkbuf_0[96]/Q[7] swmatrix_row_25_w_clkbuf_0[96]/Q[8] swmatrix_row_25_w_clkbuf_0[96]/Q[9]
+ swmatrix_row_25_w_clkbuf_0[96]/Q[10] swmatrix_row_25_w_clkbuf_0[96]/Q[11] swmatrix_row_25_w_clkbuf_0[96]/Q[12]
+ swmatrix_row_25_w_clkbuf_0[96]/Q[13] swmatrix_row_25_w_clkbuf_0[96]/Q[14] swmatrix_row_25_w_clkbuf_0[96]/Q[15]
+ swmatrix_row_25_w_clkbuf_0[96]/Q[16] swmatrix_row_25_w_clkbuf_0[96]/Q[17] swmatrix_row_25_w_clkbuf_0[96]/Q[18]
+ swmatrix_row_25_w_clkbuf_0[96]/Q[19] swmatrix_row_25_w_clkbuf_0[96]/Q[20] swmatrix_row_25_w_clkbuf_0[96]/Q[21]
+ swmatrix_row_25_w_clkbuf_0[96]/Q[22] swmatrix_row_25_w_clkbuf_0[96]/Q[23] swmatrix_row_25_w_clkbuf_0[96]/Q[24]
+ swmatrix_row_25_w_clkbuf_0[95]/D_in PIN[34] swmatrix_row_25_w_clkbuf_0[96]/Q[1]
+ swmatrix_row_25_w_clkbuf_0[96]/Q[2] swmatrix_row_25_w_clkbuf_0[96]/D_in PHI_1_in
+ BUS[20] swmatrix_row_25_w_clkbuf_0[96]/ShiftReg_row_25_0/DFF_2phase_1$1_0[23]/gf180mcu_fd_sc_mcu9t5v0__latq_1$2_1/Q
+ BUS[23] enable_in BUS[22] BUS[25] PHI_2_in BUS[8] BUS[11] BUS[2] BUS[18] VSSd BUS[14]
+ BUS[5] swmatrix_row_25_w_clkbuf
Xswmatrix_row_25_w_clkbuf_0[97] VDDd BUS[24] BUS[21] BUS[19] BUS[17] BUS[16] BUS[15]
+ BUS[13] BUS[12] BUS[10] BUS[9] BUS[7] BUS[6] BUS[4] BUS[3] BUS[1] swmatrix_row_25_w_clkbuf_0[97]/Q[3]
+ swmatrix_row_25_w_clkbuf_0[97]/Q[4] swmatrix_row_25_w_clkbuf_0[97]/Q[5] swmatrix_row_25_w_clkbuf_0[97]/Q[6]
+ swmatrix_row_25_w_clkbuf_0[97]/Q[7] swmatrix_row_25_w_clkbuf_0[97]/Q[8] swmatrix_row_25_w_clkbuf_0[97]/Q[9]
+ swmatrix_row_25_w_clkbuf_0[97]/Q[10] swmatrix_row_25_w_clkbuf_0[97]/Q[11] swmatrix_row_25_w_clkbuf_0[97]/Q[12]
+ swmatrix_row_25_w_clkbuf_0[97]/Q[13] swmatrix_row_25_w_clkbuf_0[97]/Q[14] swmatrix_row_25_w_clkbuf_0[97]/Q[15]
+ swmatrix_row_25_w_clkbuf_0[97]/Q[16] swmatrix_row_25_w_clkbuf_0[97]/Q[17] swmatrix_row_25_w_clkbuf_0[97]/Q[18]
+ swmatrix_row_25_w_clkbuf_0[97]/Q[19] swmatrix_row_25_w_clkbuf_0[97]/Q[20] swmatrix_row_25_w_clkbuf_0[97]/Q[21]
+ swmatrix_row_25_w_clkbuf_0[97]/Q[22] swmatrix_row_25_w_clkbuf_0[97]/Q[23] swmatrix_row_25_w_clkbuf_0[97]/Q[24]
+ swmatrix_row_25_w_clkbuf_0[96]/D_in PIN[33] swmatrix_row_25_w_clkbuf_0[97]/Q[1]
+ swmatrix_row_25_w_clkbuf_0[97]/Q[2] swmatrix_row_25_w_clkbuf_0[97]/D_in PHI_1_in
+ BUS[20] swmatrix_row_25_w_clkbuf_0[97]/ShiftReg_row_25_0/DFF_2phase_1$1_0[23]/gf180mcu_fd_sc_mcu9t5v0__latq_1$2_1/Q
+ BUS[23] enable_in BUS[22] BUS[25] PHI_2_in BUS[8] BUS[11] BUS[2] BUS[18] VSSd BUS[14]
+ BUS[5] swmatrix_row_25_w_clkbuf
Xswmatrix_row_25_w_clkbuf_0[98] VDDd BUS[24] BUS[21] BUS[19] BUS[17] BUS[16] BUS[15]
+ BUS[13] BUS[12] BUS[10] BUS[9] BUS[7] BUS[6] BUS[4] BUS[3] BUS[1] swmatrix_row_25_w_clkbuf_0[98]/Q[3]
+ swmatrix_row_25_w_clkbuf_0[98]/Q[4] swmatrix_row_25_w_clkbuf_0[98]/Q[5] swmatrix_row_25_w_clkbuf_0[98]/Q[6]
+ swmatrix_row_25_w_clkbuf_0[98]/Q[7] swmatrix_row_25_w_clkbuf_0[98]/Q[8] swmatrix_row_25_w_clkbuf_0[98]/Q[9]
+ swmatrix_row_25_w_clkbuf_0[98]/Q[10] swmatrix_row_25_w_clkbuf_0[98]/Q[11] swmatrix_row_25_w_clkbuf_0[98]/Q[12]
+ swmatrix_row_25_w_clkbuf_0[98]/Q[13] swmatrix_row_25_w_clkbuf_0[98]/Q[14] swmatrix_row_25_w_clkbuf_0[98]/Q[15]
+ swmatrix_row_25_w_clkbuf_0[98]/Q[16] swmatrix_row_25_w_clkbuf_0[98]/Q[17] swmatrix_row_25_w_clkbuf_0[98]/Q[18]
+ swmatrix_row_25_w_clkbuf_0[98]/Q[19] swmatrix_row_25_w_clkbuf_0[98]/Q[20] swmatrix_row_25_w_clkbuf_0[98]/Q[21]
+ swmatrix_row_25_w_clkbuf_0[98]/Q[22] swmatrix_row_25_w_clkbuf_0[98]/Q[23] swmatrix_row_25_w_clkbuf_0[98]/Q[24]
+ swmatrix_row_25_w_clkbuf_0[97]/D_in PIN[32] swmatrix_row_25_w_clkbuf_0[98]/Q[1]
+ swmatrix_row_25_w_clkbuf_0[98]/Q[2] swmatrix_row_25_w_clkbuf_0[98]/D_in PHI_1_in
+ BUS[20] swmatrix_row_25_w_clkbuf_0[98]/ShiftReg_row_25_0/DFF_2phase_1$1_0[23]/gf180mcu_fd_sc_mcu9t5v0__latq_1$2_1/Q
+ BUS[23] enable_in BUS[22] BUS[25] PHI_2_in BUS[8] BUS[11] BUS[2] BUS[18] VSSd BUS[14]
+ BUS[5] swmatrix_row_25_w_clkbuf
Xswmatrix_row_25_w_clkbuf_0[99] VDDd BUS[24] BUS[21] BUS[19] BUS[17] BUS[16] BUS[15]
+ BUS[13] BUS[12] BUS[10] BUS[9] BUS[7] BUS[6] BUS[4] BUS[3] BUS[1] swmatrix_row_25_w_clkbuf_0[99]/Q[3]
+ swmatrix_row_25_w_clkbuf_0[99]/Q[4] swmatrix_row_25_w_clkbuf_0[99]/Q[5] swmatrix_row_25_w_clkbuf_0[99]/Q[6]
+ swmatrix_row_25_w_clkbuf_0[99]/Q[7] swmatrix_row_25_w_clkbuf_0[99]/Q[8] swmatrix_row_25_w_clkbuf_0[99]/Q[9]
+ swmatrix_row_25_w_clkbuf_0[99]/Q[10] swmatrix_row_25_w_clkbuf_0[99]/Q[11] swmatrix_row_25_w_clkbuf_0[99]/Q[12]
+ swmatrix_row_25_w_clkbuf_0[99]/Q[13] swmatrix_row_25_w_clkbuf_0[99]/Q[14] swmatrix_row_25_w_clkbuf_0[99]/Q[15]
+ swmatrix_row_25_w_clkbuf_0[99]/Q[16] swmatrix_row_25_w_clkbuf_0[99]/Q[17] swmatrix_row_25_w_clkbuf_0[99]/Q[18]
+ swmatrix_row_25_w_clkbuf_0[99]/Q[19] swmatrix_row_25_w_clkbuf_0[99]/Q[20] swmatrix_row_25_w_clkbuf_0[99]/Q[21]
+ swmatrix_row_25_w_clkbuf_0[99]/Q[22] swmatrix_row_25_w_clkbuf_0[99]/Q[23] swmatrix_row_25_w_clkbuf_0[99]/Q[24]
+ swmatrix_row_25_w_clkbuf_0[98]/D_in PIN[31] swmatrix_row_25_w_clkbuf_0[99]/Q[1]
+ swmatrix_row_25_w_clkbuf_0[99]/Q[2] swmatrix_row_25_w_clkbuf_0[99]/D_in PHI_1_in
+ BUS[20] swmatrix_row_25_w_clkbuf_0[99]/ShiftReg_row_25_0/DFF_2phase_1$1_0[23]/gf180mcu_fd_sc_mcu9t5v0__latq_1$2_1/Q
+ BUS[23] enable_in BUS[22] BUS[25] PHI_2_in BUS[8] BUS[11] BUS[2] BUS[18] VSSd BUS[14]
+ BUS[5] swmatrix_row_25_w_clkbuf
Xswmatrix_row_25_w_clkbuf_0[100] VDDd BUS[24] BUS[21] BUS[19] BUS[17] BUS[16] BUS[15]
+ BUS[13] BUS[12] BUS[10] BUS[9] BUS[7] BUS[6] BUS[4] BUS[3] BUS[1] swmatrix_row_25_w_clkbuf_0[100]/Q[3]
+ swmatrix_row_25_w_clkbuf_0[100]/Q[4] swmatrix_row_25_w_clkbuf_0[100]/Q[5] swmatrix_row_25_w_clkbuf_0[100]/Q[6]
+ swmatrix_row_25_w_clkbuf_0[100]/Q[7] swmatrix_row_25_w_clkbuf_0[100]/Q[8] swmatrix_row_25_w_clkbuf_0[100]/Q[9]
+ swmatrix_row_25_w_clkbuf_0[100]/Q[10] swmatrix_row_25_w_clkbuf_0[100]/Q[11] swmatrix_row_25_w_clkbuf_0[100]/Q[12]
+ swmatrix_row_25_w_clkbuf_0[100]/Q[13] swmatrix_row_25_w_clkbuf_0[100]/Q[14] swmatrix_row_25_w_clkbuf_0[100]/Q[15]
+ swmatrix_row_25_w_clkbuf_0[100]/Q[16] swmatrix_row_25_w_clkbuf_0[100]/Q[17] swmatrix_row_25_w_clkbuf_0[100]/Q[18]
+ swmatrix_row_25_w_clkbuf_0[100]/Q[19] swmatrix_row_25_w_clkbuf_0[100]/Q[20] swmatrix_row_25_w_clkbuf_0[100]/Q[21]
+ swmatrix_row_25_w_clkbuf_0[100]/Q[22] swmatrix_row_25_w_clkbuf_0[100]/Q[23] swmatrix_row_25_w_clkbuf_0[100]/Q[24]
+ swmatrix_row_25_w_clkbuf_0[99]/D_in PIN[30] swmatrix_row_25_w_clkbuf_0[100]/Q[1]
+ swmatrix_row_25_w_clkbuf_0[100]/Q[2] swmatrix_row_25_w_clkbuf_0[100]/D_in PHI_1_in
+ BUS[20] swmatrix_row_25_w_clkbuf_0[100]/ShiftReg_row_25_0/DFF_2phase_1$1_0[23]/gf180mcu_fd_sc_mcu9t5v0__latq_1$2_1/Q
+ BUS[23] enable_in BUS[22] BUS[25] PHI_2_in BUS[8] BUS[11] BUS[2] BUS[18] VSSd BUS[14]
+ BUS[5] swmatrix_row_25_w_clkbuf
Xswmatrix_row_25_w_clkbuf_0[101] VDDd BUS[24] BUS[21] BUS[19] BUS[17] BUS[16] BUS[15]
+ BUS[13] BUS[12] BUS[10] BUS[9] BUS[7] BUS[6] BUS[4] BUS[3] BUS[1] swmatrix_row_25_w_clkbuf_0[101]/Q[3]
+ swmatrix_row_25_w_clkbuf_0[101]/Q[4] swmatrix_row_25_w_clkbuf_0[101]/Q[5] swmatrix_row_25_w_clkbuf_0[101]/Q[6]
+ swmatrix_row_25_w_clkbuf_0[101]/Q[7] swmatrix_row_25_w_clkbuf_0[101]/Q[8] swmatrix_row_25_w_clkbuf_0[101]/Q[9]
+ swmatrix_row_25_w_clkbuf_0[101]/Q[10] swmatrix_row_25_w_clkbuf_0[101]/Q[11] swmatrix_row_25_w_clkbuf_0[101]/Q[12]
+ swmatrix_row_25_w_clkbuf_0[101]/Q[13] swmatrix_row_25_w_clkbuf_0[101]/Q[14] swmatrix_row_25_w_clkbuf_0[101]/Q[15]
+ swmatrix_row_25_w_clkbuf_0[101]/Q[16] swmatrix_row_25_w_clkbuf_0[101]/Q[17] swmatrix_row_25_w_clkbuf_0[101]/Q[18]
+ swmatrix_row_25_w_clkbuf_0[101]/Q[19] swmatrix_row_25_w_clkbuf_0[101]/Q[20] swmatrix_row_25_w_clkbuf_0[101]/Q[21]
+ swmatrix_row_25_w_clkbuf_0[101]/Q[22] swmatrix_row_25_w_clkbuf_0[101]/Q[23] swmatrix_row_25_w_clkbuf_0[101]/Q[24]
+ swmatrix_row_25_w_clkbuf_0[100]/D_in PIN[29] swmatrix_row_25_w_clkbuf_0[101]/Q[1]
+ swmatrix_row_25_w_clkbuf_0[101]/Q[2] swmatrix_row_25_w_clkbuf_0[101]/D_in PHI_1_in
+ BUS[20] swmatrix_row_25_w_clkbuf_0[101]/ShiftReg_row_25_0/DFF_2phase_1$1_0[23]/gf180mcu_fd_sc_mcu9t5v0__latq_1$2_1/Q
+ BUS[23] enable_in BUS[22] BUS[25] PHI_2_in BUS[8] BUS[11] BUS[2] BUS[18] VSSd BUS[14]
+ BUS[5] swmatrix_row_25_w_clkbuf
Xswmatrix_row_25_w_clkbuf_0[102] VDDd BUS[24] BUS[21] BUS[19] BUS[17] BUS[16] BUS[15]
+ BUS[13] BUS[12] BUS[10] BUS[9] BUS[7] BUS[6] BUS[4] BUS[3] BUS[1] swmatrix_row_25_w_clkbuf_0[102]/Q[3]
+ swmatrix_row_25_w_clkbuf_0[102]/Q[4] swmatrix_row_25_w_clkbuf_0[102]/Q[5] swmatrix_row_25_w_clkbuf_0[102]/Q[6]
+ swmatrix_row_25_w_clkbuf_0[102]/Q[7] swmatrix_row_25_w_clkbuf_0[102]/Q[8] swmatrix_row_25_w_clkbuf_0[102]/Q[9]
+ swmatrix_row_25_w_clkbuf_0[102]/Q[10] swmatrix_row_25_w_clkbuf_0[102]/Q[11] swmatrix_row_25_w_clkbuf_0[102]/Q[12]
+ swmatrix_row_25_w_clkbuf_0[102]/Q[13] swmatrix_row_25_w_clkbuf_0[102]/Q[14] swmatrix_row_25_w_clkbuf_0[102]/Q[15]
+ swmatrix_row_25_w_clkbuf_0[102]/Q[16] swmatrix_row_25_w_clkbuf_0[102]/Q[17] swmatrix_row_25_w_clkbuf_0[102]/Q[18]
+ swmatrix_row_25_w_clkbuf_0[102]/Q[19] swmatrix_row_25_w_clkbuf_0[102]/Q[20] swmatrix_row_25_w_clkbuf_0[102]/Q[21]
+ swmatrix_row_25_w_clkbuf_0[102]/Q[22] swmatrix_row_25_w_clkbuf_0[102]/Q[23] swmatrix_row_25_w_clkbuf_0[102]/Q[24]
+ swmatrix_row_25_w_clkbuf_0[101]/D_in PIN[28] swmatrix_row_25_w_clkbuf_0[102]/Q[1]
+ swmatrix_row_25_w_clkbuf_0[102]/Q[2] swmatrix_row_25_w_clkbuf_0[102]/D_in PHI_1_in
+ BUS[20] swmatrix_row_25_w_clkbuf_0[102]/ShiftReg_row_25_0/DFF_2phase_1$1_0[23]/gf180mcu_fd_sc_mcu9t5v0__latq_1$2_1/Q
+ BUS[23] enable_in BUS[22] BUS[25] PHI_2_in BUS[8] BUS[11] BUS[2] BUS[18] VSSd BUS[14]
+ BUS[5] swmatrix_row_25_w_clkbuf
Xswmatrix_row_25_w_clkbuf_0[103] VDDd BUS[24] BUS[21] BUS[19] BUS[17] BUS[16] BUS[15]
+ BUS[13] BUS[12] BUS[10] BUS[9] BUS[7] BUS[6] BUS[4] BUS[3] BUS[1] swmatrix_row_25_w_clkbuf_0[103]/Q[3]
+ swmatrix_row_25_w_clkbuf_0[103]/Q[4] swmatrix_row_25_w_clkbuf_0[103]/Q[5] swmatrix_row_25_w_clkbuf_0[103]/Q[6]
+ swmatrix_row_25_w_clkbuf_0[103]/Q[7] swmatrix_row_25_w_clkbuf_0[103]/Q[8] swmatrix_row_25_w_clkbuf_0[103]/Q[9]
+ swmatrix_row_25_w_clkbuf_0[103]/Q[10] swmatrix_row_25_w_clkbuf_0[103]/Q[11] swmatrix_row_25_w_clkbuf_0[103]/Q[12]
+ swmatrix_row_25_w_clkbuf_0[103]/Q[13] swmatrix_row_25_w_clkbuf_0[103]/Q[14] swmatrix_row_25_w_clkbuf_0[103]/Q[15]
+ swmatrix_row_25_w_clkbuf_0[103]/Q[16] swmatrix_row_25_w_clkbuf_0[103]/Q[17] swmatrix_row_25_w_clkbuf_0[103]/Q[18]
+ swmatrix_row_25_w_clkbuf_0[103]/Q[19] swmatrix_row_25_w_clkbuf_0[103]/Q[20] swmatrix_row_25_w_clkbuf_0[103]/Q[21]
+ swmatrix_row_25_w_clkbuf_0[103]/Q[22] swmatrix_row_25_w_clkbuf_0[103]/Q[23] swmatrix_row_25_w_clkbuf_0[103]/Q[24]
+ swmatrix_row_25_w_clkbuf_0[102]/D_in PIN[27] swmatrix_row_25_w_clkbuf_0[103]/Q[1]
+ swmatrix_row_25_w_clkbuf_0[103]/Q[2] swmatrix_row_25_w_clkbuf_0[103]/D_in PHI_1_in
+ BUS[20] swmatrix_row_25_w_clkbuf_0[103]/ShiftReg_row_25_0/DFF_2phase_1$1_0[23]/gf180mcu_fd_sc_mcu9t5v0__latq_1$2_1/Q
+ BUS[23] enable_in BUS[22] BUS[25] PHI_2_in BUS[8] BUS[11] BUS[2] BUS[18] VSSd BUS[14]
+ BUS[5] swmatrix_row_25_w_clkbuf
Xswmatrix_row_25_w_clkbuf_0[104] VDDd BUS[24] BUS[21] BUS[19] BUS[17] BUS[16] BUS[15]
+ BUS[13] BUS[12] BUS[10] BUS[9] BUS[7] BUS[6] BUS[4] BUS[3] BUS[1] swmatrix_row_25_w_clkbuf_0[104]/Q[3]
+ swmatrix_row_25_w_clkbuf_0[104]/Q[4] swmatrix_row_25_w_clkbuf_0[104]/Q[5] swmatrix_row_25_w_clkbuf_0[104]/Q[6]
+ swmatrix_row_25_w_clkbuf_0[104]/Q[7] swmatrix_row_25_w_clkbuf_0[104]/Q[8] swmatrix_row_25_w_clkbuf_0[104]/Q[9]
+ swmatrix_row_25_w_clkbuf_0[104]/Q[10] swmatrix_row_25_w_clkbuf_0[104]/Q[11] swmatrix_row_25_w_clkbuf_0[104]/Q[12]
+ swmatrix_row_25_w_clkbuf_0[104]/Q[13] swmatrix_row_25_w_clkbuf_0[104]/Q[14] swmatrix_row_25_w_clkbuf_0[104]/Q[15]
+ swmatrix_row_25_w_clkbuf_0[104]/Q[16] swmatrix_row_25_w_clkbuf_0[104]/Q[17] swmatrix_row_25_w_clkbuf_0[104]/Q[18]
+ swmatrix_row_25_w_clkbuf_0[104]/Q[19] swmatrix_row_25_w_clkbuf_0[104]/Q[20] swmatrix_row_25_w_clkbuf_0[104]/Q[21]
+ swmatrix_row_25_w_clkbuf_0[104]/Q[22] swmatrix_row_25_w_clkbuf_0[104]/Q[23] swmatrix_row_25_w_clkbuf_0[104]/Q[24]
+ swmatrix_row_25_w_clkbuf_0[103]/D_in PIN[26] swmatrix_row_25_w_clkbuf_0[104]/Q[1]
+ swmatrix_row_25_w_clkbuf_0[104]/Q[2] swmatrix_row_25_w_clkbuf_0[104]/D_in PHI_1_in
+ BUS[20] swmatrix_row_25_w_clkbuf_0[104]/ShiftReg_row_25_0/DFF_2phase_1$1_0[23]/gf180mcu_fd_sc_mcu9t5v0__latq_1$2_1/Q
+ BUS[23] enable_in BUS[22] BUS[25] PHI_2_in BUS[8] BUS[11] BUS[2] BUS[18] VSSd BUS[14]
+ BUS[5] swmatrix_row_25_w_clkbuf
Xswmatrix_row_25_w_clkbuf_0[105] VDDd BUS[24] BUS[21] BUS[19] BUS[17] BUS[16] BUS[15]
+ BUS[13] BUS[12] BUS[10] BUS[9] BUS[7] BUS[6] BUS[4] BUS[3] BUS[1] swmatrix_row_25_w_clkbuf_0[105]/Q[3]
+ swmatrix_row_25_w_clkbuf_0[105]/Q[4] swmatrix_row_25_w_clkbuf_0[105]/Q[5] swmatrix_row_25_w_clkbuf_0[105]/Q[6]
+ swmatrix_row_25_w_clkbuf_0[105]/Q[7] swmatrix_row_25_w_clkbuf_0[105]/Q[8] swmatrix_row_25_w_clkbuf_0[105]/Q[9]
+ swmatrix_row_25_w_clkbuf_0[105]/Q[10] swmatrix_row_25_w_clkbuf_0[105]/Q[11] swmatrix_row_25_w_clkbuf_0[105]/Q[12]
+ swmatrix_row_25_w_clkbuf_0[105]/Q[13] swmatrix_row_25_w_clkbuf_0[105]/Q[14] swmatrix_row_25_w_clkbuf_0[105]/Q[15]
+ swmatrix_row_25_w_clkbuf_0[105]/Q[16] swmatrix_row_25_w_clkbuf_0[105]/Q[17] swmatrix_row_25_w_clkbuf_0[105]/Q[18]
+ swmatrix_row_25_w_clkbuf_0[105]/Q[19] swmatrix_row_25_w_clkbuf_0[105]/Q[20] swmatrix_row_25_w_clkbuf_0[105]/Q[21]
+ swmatrix_row_25_w_clkbuf_0[105]/Q[22] swmatrix_row_25_w_clkbuf_0[105]/Q[23] swmatrix_row_25_w_clkbuf_0[105]/Q[24]
+ swmatrix_row_25_w_clkbuf_0[104]/D_in PIN[25] swmatrix_row_25_w_clkbuf_0[105]/Q[1]
+ swmatrix_row_25_w_clkbuf_0[105]/Q[2] swmatrix_row_25_w_clkbuf_0[105]/D_in PHI_1_in
+ BUS[20] swmatrix_row_25_w_clkbuf_0[105]/ShiftReg_row_25_0/DFF_2phase_1$1_0[23]/gf180mcu_fd_sc_mcu9t5v0__latq_1$2_1/Q
+ BUS[23] enable_in BUS[22] BUS[25] PHI_2_in BUS[8] BUS[11] BUS[2] BUS[18] VSSd BUS[14]
+ BUS[5] swmatrix_row_25_w_clkbuf
Xswmatrix_row_25_w_clkbuf_0[106] VDDd BUS[24] BUS[21] BUS[19] BUS[17] BUS[16] BUS[15]
+ BUS[13] BUS[12] BUS[10] BUS[9] BUS[7] BUS[6] BUS[4] BUS[3] BUS[1] swmatrix_row_25_w_clkbuf_0[106]/Q[3]
+ swmatrix_row_25_w_clkbuf_0[106]/Q[4] swmatrix_row_25_w_clkbuf_0[106]/Q[5] swmatrix_row_25_w_clkbuf_0[106]/Q[6]
+ swmatrix_row_25_w_clkbuf_0[106]/Q[7] swmatrix_row_25_w_clkbuf_0[106]/Q[8] swmatrix_row_25_w_clkbuf_0[106]/Q[9]
+ swmatrix_row_25_w_clkbuf_0[106]/Q[10] swmatrix_row_25_w_clkbuf_0[106]/Q[11] swmatrix_row_25_w_clkbuf_0[106]/Q[12]
+ swmatrix_row_25_w_clkbuf_0[106]/Q[13] swmatrix_row_25_w_clkbuf_0[106]/Q[14] swmatrix_row_25_w_clkbuf_0[106]/Q[15]
+ swmatrix_row_25_w_clkbuf_0[106]/Q[16] swmatrix_row_25_w_clkbuf_0[106]/Q[17] swmatrix_row_25_w_clkbuf_0[106]/Q[18]
+ swmatrix_row_25_w_clkbuf_0[106]/Q[19] swmatrix_row_25_w_clkbuf_0[106]/Q[20] swmatrix_row_25_w_clkbuf_0[106]/Q[21]
+ swmatrix_row_25_w_clkbuf_0[106]/Q[22] swmatrix_row_25_w_clkbuf_0[106]/Q[23] swmatrix_row_25_w_clkbuf_0[106]/Q[24]
+ swmatrix_row_25_w_clkbuf_0[105]/D_in PIN[24] swmatrix_row_25_w_clkbuf_0[106]/Q[1]
+ swmatrix_row_25_w_clkbuf_0[106]/Q[2] swmatrix_row_25_w_clkbuf_0[106]/D_in PHI_1_in
+ BUS[20] swmatrix_row_25_w_clkbuf_0[106]/ShiftReg_row_25_0/DFF_2phase_1$1_0[23]/gf180mcu_fd_sc_mcu9t5v0__latq_1$2_1/Q
+ BUS[23] enable_in BUS[22] BUS[25] PHI_2_in BUS[8] BUS[11] BUS[2] BUS[18] VSSd BUS[14]
+ BUS[5] swmatrix_row_25_w_clkbuf
Xswmatrix_row_25_w_clkbuf_0[107] VDDd BUS[24] BUS[21] BUS[19] BUS[17] BUS[16] BUS[15]
+ BUS[13] BUS[12] BUS[10] BUS[9] BUS[7] BUS[6] BUS[4] BUS[3] BUS[1] swmatrix_row_25_w_clkbuf_0[107]/Q[3]
+ swmatrix_row_25_w_clkbuf_0[107]/Q[4] swmatrix_row_25_w_clkbuf_0[107]/Q[5] swmatrix_row_25_w_clkbuf_0[107]/Q[6]
+ swmatrix_row_25_w_clkbuf_0[107]/Q[7] swmatrix_row_25_w_clkbuf_0[107]/Q[8] swmatrix_row_25_w_clkbuf_0[107]/Q[9]
+ swmatrix_row_25_w_clkbuf_0[107]/Q[10] swmatrix_row_25_w_clkbuf_0[107]/Q[11] swmatrix_row_25_w_clkbuf_0[107]/Q[12]
+ swmatrix_row_25_w_clkbuf_0[107]/Q[13] swmatrix_row_25_w_clkbuf_0[107]/Q[14] swmatrix_row_25_w_clkbuf_0[107]/Q[15]
+ swmatrix_row_25_w_clkbuf_0[107]/Q[16] swmatrix_row_25_w_clkbuf_0[107]/Q[17] swmatrix_row_25_w_clkbuf_0[107]/Q[18]
+ swmatrix_row_25_w_clkbuf_0[107]/Q[19] swmatrix_row_25_w_clkbuf_0[107]/Q[20] swmatrix_row_25_w_clkbuf_0[107]/Q[21]
+ swmatrix_row_25_w_clkbuf_0[107]/Q[22] swmatrix_row_25_w_clkbuf_0[107]/Q[23] swmatrix_row_25_w_clkbuf_0[107]/Q[24]
+ swmatrix_row_25_w_clkbuf_0[106]/D_in PIN[23] swmatrix_row_25_w_clkbuf_0[107]/Q[1]
+ swmatrix_row_25_w_clkbuf_0[107]/Q[2] swmatrix_row_25_w_clkbuf_0[107]/D_in PHI_1_in
+ BUS[20] swmatrix_row_25_w_clkbuf_0[107]/ShiftReg_row_25_0/DFF_2phase_1$1_0[23]/gf180mcu_fd_sc_mcu9t5v0__latq_1$2_1/Q
+ BUS[23] enable_in BUS[22] BUS[25] PHI_2_in BUS[8] BUS[11] BUS[2] BUS[18] VSSd BUS[14]
+ BUS[5] swmatrix_row_25_w_clkbuf
Xswmatrix_row_25_w_clkbuf_0[108] VDDd BUS[24] BUS[21] BUS[19] BUS[17] BUS[16] BUS[15]
+ BUS[13] BUS[12] BUS[10] BUS[9] BUS[7] BUS[6] BUS[4] BUS[3] BUS[1] swmatrix_row_25_w_clkbuf_0[108]/Q[3]
+ swmatrix_row_25_w_clkbuf_0[108]/Q[4] swmatrix_row_25_w_clkbuf_0[108]/Q[5] swmatrix_row_25_w_clkbuf_0[108]/Q[6]
+ swmatrix_row_25_w_clkbuf_0[108]/Q[7] swmatrix_row_25_w_clkbuf_0[108]/Q[8] swmatrix_row_25_w_clkbuf_0[108]/Q[9]
+ swmatrix_row_25_w_clkbuf_0[108]/Q[10] swmatrix_row_25_w_clkbuf_0[108]/Q[11] swmatrix_row_25_w_clkbuf_0[108]/Q[12]
+ swmatrix_row_25_w_clkbuf_0[108]/Q[13] swmatrix_row_25_w_clkbuf_0[108]/Q[14] swmatrix_row_25_w_clkbuf_0[108]/Q[15]
+ swmatrix_row_25_w_clkbuf_0[108]/Q[16] swmatrix_row_25_w_clkbuf_0[108]/Q[17] swmatrix_row_25_w_clkbuf_0[108]/Q[18]
+ swmatrix_row_25_w_clkbuf_0[108]/Q[19] swmatrix_row_25_w_clkbuf_0[108]/Q[20] swmatrix_row_25_w_clkbuf_0[108]/Q[21]
+ swmatrix_row_25_w_clkbuf_0[108]/Q[22] swmatrix_row_25_w_clkbuf_0[108]/Q[23] swmatrix_row_25_w_clkbuf_0[108]/Q[24]
+ swmatrix_row_25_w_clkbuf_0[107]/D_in PIN[22] swmatrix_row_25_w_clkbuf_0[108]/Q[1]
+ swmatrix_row_25_w_clkbuf_0[108]/Q[2] swmatrix_row_25_w_clkbuf_0[108]/D_in PHI_1_in
+ BUS[20] swmatrix_row_25_w_clkbuf_0[108]/ShiftReg_row_25_0/DFF_2phase_1$1_0[23]/gf180mcu_fd_sc_mcu9t5v0__latq_1$2_1/Q
+ BUS[23] enable_in BUS[22] BUS[25] PHI_2_in BUS[8] BUS[11] BUS[2] BUS[18] VSSd BUS[14]
+ BUS[5] swmatrix_row_25_w_clkbuf
Xswmatrix_row_25_w_clkbuf_0[109] VDDd BUS[24] BUS[21] BUS[19] BUS[17] BUS[16] BUS[15]
+ BUS[13] BUS[12] BUS[10] BUS[9] BUS[7] BUS[6] BUS[4] BUS[3] BUS[1] swmatrix_row_25_w_clkbuf_0[109]/Q[3]
+ swmatrix_row_25_w_clkbuf_0[109]/Q[4] swmatrix_row_25_w_clkbuf_0[109]/Q[5] swmatrix_row_25_w_clkbuf_0[109]/Q[6]
+ swmatrix_row_25_w_clkbuf_0[109]/Q[7] swmatrix_row_25_w_clkbuf_0[109]/Q[8] swmatrix_row_25_w_clkbuf_0[109]/Q[9]
+ swmatrix_row_25_w_clkbuf_0[109]/Q[10] swmatrix_row_25_w_clkbuf_0[109]/Q[11] swmatrix_row_25_w_clkbuf_0[109]/Q[12]
+ swmatrix_row_25_w_clkbuf_0[109]/Q[13] swmatrix_row_25_w_clkbuf_0[109]/Q[14] swmatrix_row_25_w_clkbuf_0[109]/Q[15]
+ swmatrix_row_25_w_clkbuf_0[109]/Q[16] swmatrix_row_25_w_clkbuf_0[109]/Q[17] swmatrix_row_25_w_clkbuf_0[109]/Q[18]
+ swmatrix_row_25_w_clkbuf_0[109]/Q[19] swmatrix_row_25_w_clkbuf_0[109]/Q[20] swmatrix_row_25_w_clkbuf_0[109]/Q[21]
+ swmatrix_row_25_w_clkbuf_0[109]/Q[22] swmatrix_row_25_w_clkbuf_0[109]/Q[23] swmatrix_row_25_w_clkbuf_0[109]/Q[24]
+ swmatrix_row_25_w_clkbuf_0[108]/D_in PIN[21] swmatrix_row_25_w_clkbuf_0[109]/Q[1]
+ swmatrix_row_25_w_clkbuf_0[109]/Q[2] swmatrix_row_25_w_clkbuf_0[109]/D_in PHI_1_in
+ BUS[20] swmatrix_row_25_w_clkbuf_0[109]/ShiftReg_row_25_0/DFF_2phase_1$1_0[23]/gf180mcu_fd_sc_mcu9t5v0__latq_1$2_1/Q
+ BUS[23] enable_in BUS[22] BUS[25] PHI_2_in BUS[8] BUS[11] BUS[2] BUS[18] VSSd BUS[14]
+ BUS[5] swmatrix_row_25_w_clkbuf
Xswmatrix_row_25_w_clkbuf_0[110] VDDd BUS[24] BUS[21] BUS[19] BUS[17] BUS[16] BUS[15]
+ BUS[13] BUS[12] BUS[10] BUS[9] BUS[7] BUS[6] BUS[4] BUS[3] BUS[1] swmatrix_row_25_w_clkbuf_0[110]/Q[3]
+ swmatrix_row_25_w_clkbuf_0[110]/Q[4] swmatrix_row_25_w_clkbuf_0[110]/Q[5] swmatrix_row_25_w_clkbuf_0[110]/Q[6]
+ swmatrix_row_25_w_clkbuf_0[110]/Q[7] swmatrix_row_25_w_clkbuf_0[110]/Q[8] swmatrix_row_25_w_clkbuf_0[110]/Q[9]
+ swmatrix_row_25_w_clkbuf_0[110]/Q[10] swmatrix_row_25_w_clkbuf_0[110]/Q[11] swmatrix_row_25_w_clkbuf_0[110]/Q[12]
+ swmatrix_row_25_w_clkbuf_0[110]/Q[13] swmatrix_row_25_w_clkbuf_0[110]/Q[14] swmatrix_row_25_w_clkbuf_0[110]/Q[15]
+ swmatrix_row_25_w_clkbuf_0[110]/Q[16] swmatrix_row_25_w_clkbuf_0[110]/Q[17] swmatrix_row_25_w_clkbuf_0[110]/Q[18]
+ swmatrix_row_25_w_clkbuf_0[110]/Q[19] swmatrix_row_25_w_clkbuf_0[110]/Q[20] swmatrix_row_25_w_clkbuf_0[110]/Q[21]
+ swmatrix_row_25_w_clkbuf_0[110]/Q[22] swmatrix_row_25_w_clkbuf_0[110]/Q[23] swmatrix_row_25_w_clkbuf_0[110]/Q[24]
+ swmatrix_row_25_w_clkbuf_0[109]/D_in PIN[20] swmatrix_row_25_w_clkbuf_0[110]/Q[1]
+ swmatrix_row_25_w_clkbuf_0[110]/Q[2] swmatrix_row_25_w_clkbuf_0[110]/D_in PHI_1_in
+ BUS[20] swmatrix_row_25_w_clkbuf_0[110]/ShiftReg_row_25_0/DFF_2phase_1$1_0[23]/gf180mcu_fd_sc_mcu9t5v0__latq_1$2_1/Q
+ BUS[23] enable_in BUS[22] BUS[25] PHI_2_in BUS[8] BUS[11] BUS[2] BUS[18] VSSd BUS[14]
+ BUS[5] swmatrix_row_25_w_clkbuf
Xswmatrix_row_25_w_clkbuf_0[111] VDDd BUS[24] BUS[21] BUS[19] BUS[17] BUS[16] BUS[15]
+ BUS[13] BUS[12] BUS[10] BUS[9] BUS[7] BUS[6] BUS[4] BUS[3] BUS[1] swmatrix_row_25_w_clkbuf_0[111]/Q[3]
+ swmatrix_row_25_w_clkbuf_0[111]/Q[4] swmatrix_row_25_w_clkbuf_0[111]/Q[5] swmatrix_row_25_w_clkbuf_0[111]/Q[6]
+ swmatrix_row_25_w_clkbuf_0[111]/Q[7] swmatrix_row_25_w_clkbuf_0[111]/Q[8] swmatrix_row_25_w_clkbuf_0[111]/Q[9]
+ swmatrix_row_25_w_clkbuf_0[111]/Q[10] swmatrix_row_25_w_clkbuf_0[111]/Q[11] swmatrix_row_25_w_clkbuf_0[111]/Q[12]
+ swmatrix_row_25_w_clkbuf_0[111]/Q[13] swmatrix_row_25_w_clkbuf_0[111]/Q[14] swmatrix_row_25_w_clkbuf_0[111]/Q[15]
+ swmatrix_row_25_w_clkbuf_0[111]/Q[16] swmatrix_row_25_w_clkbuf_0[111]/Q[17] swmatrix_row_25_w_clkbuf_0[111]/Q[18]
+ swmatrix_row_25_w_clkbuf_0[111]/Q[19] swmatrix_row_25_w_clkbuf_0[111]/Q[20] swmatrix_row_25_w_clkbuf_0[111]/Q[21]
+ swmatrix_row_25_w_clkbuf_0[111]/Q[22] swmatrix_row_25_w_clkbuf_0[111]/Q[23] swmatrix_row_25_w_clkbuf_0[111]/Q[24]
+ swmatrix_row_25_w_clkbuf_0[110]/D_in PIN[19] swmatrix_row_25_w_clkbuf_0[111]/Q[1]
+ swmatrix_row_25_w_clkbuf_0[111]/Q[2] swmatrix_row_25_w_clkbuf_0[111]/D_in PHI_1_in
+ BUS[20] swmatrix_row_25_w_clkbuf_0[111]/ShiftReg_row_25_0/DFF_2phase_1$1_0[23]/gf180mcu_fd_sc_mcu9t5v0__latq_1$2_1/Q
+ BUS[23] enable_in BUS[22] BUS[25] PHI_2_in BUS[8] BUS[11] BUS[2] BUS[18] VSSd BUS[14]
+ BUS[5] swmatrix_row_25_w_clkbuf
Xswmatrix_row_25_w_clkbuf_0[112] VDDd BUS[24] BUS[21] BUS[19] BUS[17] BUS[16] BUS[15]
+ BUS[13] BUS[12] BUS[10] BUS[9] BUS[7] BUS[6] BUS[4] BUS[3] BUS[1] swmatrix_row_25_w_clkbuf_0[112]/Q[3]
+ swmatrix_row_25_w_clkbuf_0[112]/Q[4] swmatrix_row_25_w_clkbuf_0[112]/Q[5] swmatrix_row_25_w_clkbuf_0[112]/Q[6]
+ swmatrix_row_25_w_clkbuf_0[112]/Q[7] swmatrix_row_25_w_clkbuf_0[112]/Q[8] swmatrix_row_25_w_clkbuf_0[112]/Q[9]
+ swmatrix_row_25_w_clkbuf_0[112]/Q[10] swmatrix_row_25_w_clkbuf_0[112]/Q[11] swmatrix_row_25_w_clkbuf_0[112]/Q[12]
+ swmatrix_row_25_w_clkbuf_0[112]/Q[13] swmatrix_row_25_w_clkbuf_0[112]/Q[14] swmatrix_row_25_w_clkbuf_0[112]/Q[15]
+ swmatrix_row_25_w_clkbuf_0[112]/Q[16] swmatrix_row_25_w_clkbuf_0[112]/Q[17] swmatrix_row_25_w_clkbuf_0[112]/Q[18]
+ swmatrix_row_25_w_clkbuf_0[112]/Q[19] swmatrix_row_25_w_clkbuf_0[112]/Q[20] swmatrix_row_25_w_clkbuf_0[112]/Q[21]
+ swmatrix_row_25_w_clkbuf_0[112]/Q[22] swmatrix_row_25_w_clkbuf_0[112]/Q[23] swmatrix_row_25_w_clkbuf_0[112]/Q[24]
+ swmatrix_row_25_w_clkbuf_0[111]/D_in PIN[18] swmatrix_row_25_w_clkbuf_0[112]/Q[1]
+ swmatrix_row_25_w_clkbuf_0[112]/Q[2] swmatrix_row_25_w_clkbuf_0[112]/D_in PHI_1_in
+ BUS[20] swmatrix_row_25_w_clkbuf_0[112]/ShiftReg_row_25_0/DFF_2phase_1$1_0[23]/gf180mcu_fd_sc_mcu9t5v0__latq_1$2_1/Q
+ BUS[23] enable_in BUS[22] BUS[25] PHI_2_in BUS[8] BUS[11] BUS[2] BUS[18] VSSd BUS[14]
+ BUS[5] swmatrix_row_25_w_clkbuf
Xswmatrix_row_25_w_clkbuf_0[113] VDDd BUS[24] BUS[21] BUS[19] BUS[17] BUS[16] BUS[15]
+ BUS[13] BUS[12] BUS[10] BUS[9] BUS[7] BUS[6] BUS[4] BUS[3] BUS[1] swmatrix_row_25_w_clkbuf_0[113]/Q[3]
+ swmatrix_row_25_w_clkbuf_0[113]/Q[4] swmatrix_row_25_w_clkbuf_0[113]/Q[5] swmatrix_row_25_w_clkbuf_0[113]/Q[6]
+ swmatrix_row_25_w_clkbuf_0[113]/Q[7] swmatrix_row_25_w_clkbuf_0[113]/Q[8] swmatrix_row_25_w_clkbuf_0[113]/Q[9]
+ swmatrix_row_25_w_clkbuf_0[113]/Q[10] swmatrix_row_25_w_clkbuf_0[113]/Q[11] swmatrix_row_25_w_clkbuf_0[113]/Q[12]
+ swmatrix_row_25_w_clkbuf_0[113]/Q[13] swmatrix_row_25_w_clkbuf_0[113]/Q[14] swmatrix_row_25_w_clkbuf_0[113]/Q[15]
+ swmatrix_row_25_w_clkbuf_0[113]/Q[16] swmatrix_row_25_w_clkbuf_0[113]/Q[17] swmatrix_row_25_w_clkbuf_0[113]/Q[18]
+ swmatrix_row_25_w_clkbuf_0[113]/Q[19] swmatrix_row_25_w_clkbuf_0[113]/Q[20] swmatrix_row_25_w_clkbuf_0[113]/Q[21]
+ swmatrix_row_25_w_clkbuf_0[113]/Q[22] swmatrix_row_25_w_clkbuf_0[113]/Q[23] swmatrix_row_25_w_clkbuf_0[113]/Q[24]
+ swmatrix_row_25_w_clkbuf_0[112]/D_in PIN[17] swmatrix_row_25_w_clkbuf_0[113]/Q[1]
+ swmatrix_row_25_w_clkbuf_0[113]/Q[2] swmatrix_row_25_w_clkbuf_0[113]/D_in PHI_1_in
+ BUS[20] swmatrix_row_25_w_clkbuf_0[113]/ShiftReg_row_25_0/DFF_2phase_1$1_0[23]/gf180mcu_fd_sc_mcu9t5v0__latq_1$2_1/Q
+ BUS[23] enable_in BUS[22] BUS[25] PHI_2_in BUS[8] BUS[11] BUS[2] BUS[18] VSSd BUS[14]
+ BUS[5] swmatrix_row_25_w_clkbuf
Xswmatrix_row_25_w_clkbuf_0[114] VDDd BUS[24] BUS[21] BUS[19] BUS[17] BUS[16] BUS[15]
+ BUS[13] BUS[12] BUS[10] BUS[9] BUS[7] BUS[6] BUS[4] BUS[3] BUS[1] swmatrix_row_25_w_clkbuf_0[114]/Q[3]
+ swmatrix_row_25_w_clkbuf_0[114]/Q[4] swmatrix_row_25_w_clkbuf_0[114]/Q[5] swmatrix_row_25_w_clkbuf_0[114]/Q[6]
+ swmatrix_row_25_w_clkbuf_0[114]/Q[7] swmatrix_row_25_w_clkbuf_0[114]/Q[8] swmatrix_row_25_w_clkbuf_0[114]/Q[9]
+ swmatrix_row_25_w_clkbuf_0[114]/Q[10] swmatrix_row_25_w_clkbuf_0[114]/Q[11] swmatrix_row_25_w_clkbuf_0[114]/Q[12]
+ swmatrix_row_25_w_clkbuf_0[114]/Q[13] swmatrix_row_25_w_clkbuf_0[114]/Q[14] swmatrix_row_25_w_clkbuf_0[114]/Q[15]
+ swmatrix_row_25_w_clkbuf_0[114]/Q[16] swmatrix_row_25_w_clkbuf_0[114]/Q[17] swmatrix_row_25_w_clkbuf_0[114]/Q[18]
+ swmatrix_row_25_w_clkbuf_0[114]/Q[19] swmatrix_row_25_w_clkbuf_0[114]/Q[20] swmatrix_row_25_w_clkbuf_0[114]/Q[21]
+ swmatrix_row_25_w_clkbuf_0[114]/Q[22] swmatrix_row_25_w_clkbuf_0[114]/Q[23] swmatrix_row_25_w_clkbuf_0[114]/Q[24]
+ swmatrix_row_25_w_clkbuf_0[113]/D_in PIN[16] swmatrix_row_25_w_clkbuf_0[114]/Q[1]
+ swmatrix_row_25_w_clkbuf_0[114]/Q[2] swmatrix_row_25_w_clkbuf_0[114]/D_in PHI_1_in
+ BUS[20] swmatrix_row_25_w_clkbuf_0[114]/ShiftReg_row_25_0/DFF_2phase_1$1_0[23]/gf180mcu_fd_sc_mcu9t5v0__latq_1$2_1/Q
+ BUS[23] enable_in BUS[22] BUS[25] PHI_2_in BUS[8] BUS[11] BUS[2] BUS[18] VSSd BUS[14]
+ BUS[5] swmatrix_row_25_w_clkbuf
Xswmatrix_row_25_w_clkbuf_0[115] VDDd BUS[24] BUS[21] BUS[19] BUS[17] BUS[16] BUS[15]
+ BUS[13] BUS[12] BUS[10] BUS[9] BUS[7] BUS[6] BUS[4] BUS[3] BUS[1] swmatrix_row_25_w_clkbuf_0[115]/Q[3]
+ swmatrix_row_25_w_clkbuf_0[115]/Q[4] swmatrix_row_25_w_clkbuf_0[115]/Q[5] swmatrix_row_25_w_clkbuf_0[115]/Q[6]
+ swmatrix_row_25_w_clkbuf_0[115]/Q[7] swmatrix_row_25_w_clkbuf_0[115]/Q[8] swmatrix_row_25_w_clkbuf_0[115]/Q[9]
+ swmatrix_row_25_w_clkbuf_0[115]/Q[10] swmatrix_row_25_w_clkbuf_0[115]/Q[11] swmatrix_row_25_w_clkbuf_0[115]/Q[12]
+ swmatrix_row_25_w_clkbuf_0[115]/Q[13] swmatrix_row_25_w_clkbuf_0[115]/Q[14] swmatrix_row_25_w_clkbuf_0[115]/Q[15]
+ swmatrix_row_25_w_clkbuf_0[115]/Q[16] swmatrix_row_25_w_clkbuf_0[115]/Q[17] swmatrix_row_25_w_clkbuf_0[115]/Q[18]
+ swmatrix_row_25_w_clkbuf_0[115]/Q[19] swmatrix_row_25_w_clkbuf_0[115]/Q[20] swmatrix_row_25_w_clkbuf_0[115]/Q[21]
+ swmatrix_row_25_w_clkbuf_0[115]/Q[22] swmatrix_row_25_w_clkbuf_0[115]/Q[23] swmatrix_row_25_w_clkbuf_0[115]/Q[24]
+ swmatrix_row_25_w_clkbuf_0[114]/D_in PIN[15] swmatrix_row_25_w_clkbuf_0[115]/Q[1]
+ swmatrix_row_25_w_clkbuf_0[115]/Q[2] swmatrix_row_25_w_clkbuf_0[115]/D_in PHI_1_in
+ BUS[20] swmatrix_row_25_w_clkbuf_0[115]/ShiftReg_row_25_0/DFF_2phase_1$1_0[23]/gf180mcu_fd_sc_mcu9t5v0__latq_1$2_1/Q
+ BUS[23] enable_in BUS[22] BUS[25] PHI_2_in BUS[8] BUS[11] BUS[2] BUS[18] VSSd BUS[14]
+ BUS[5] swmatrix_row_25_w_clkbuf
Xswmatrix_row_25_w_clkbuf_0[116] VDDd BUS[24] BUS[21] BUS[19] BUS[17] BUS[16] BUS[15]
+ BUS[13] BUS[12] BUS[10] BUS[9] BUS[7] BUS[6] BUS[4] BUS[3] BUS[1] swmatrix_row_25_w_clkbuf_0[116]/Q[3]
+ swmatrix_row_25_w_clkbuf_0[116]/Q[4] swmatrix_row_25_w_clkbuf_0[116]/Q[5] swmatrix_row_25_w_clkbuf_0[116]/Q[6]
+ swmatrix_row_25_w_clkbuf_0[116]/Q[7] swmatrix_row_25_w_clkbuf_0[116]/Q[8] swmatrix_row_25_w_clkbuf_0[116]/Q[9]
+ swmatrix_row_25_w_clkbuf_0[116]/Q[10] swmatrix_row_25_w_clkbuf_0[116]/Q[11] swmatrix_row_25_w_clkbuf_0[116]/Q[12]
+ swmatrix_row_25_w_clkbuf_0[116]/Q[13] swmatrix_row_25_w_clkbuf_0[116]/Q[14] swmatrix_row_25_w_clkbuf_0[116]/Q[15]
+ swmatrix_row_25_w_clkbuf_0[116]/Q[16] swmatrix_row_25_w_clkbuf_0[116]/Q[17] swmatrix_row_25_w_clkbuf_0[116]/Q[18]
+ swmatrix_row_25_w_clkbuf_0[116]/Q[19] swmatrix_row_25_w_clkbuf_0[116]/Q[20] swmatrix_row_25_w_clkbuf_0[116]/Q[21]
+ swmatrix_row_25_w_clkbuf_0[116]/Q[22] swmatrix_row_25_w_clkbuf_0[116]/Q[23] swmatrix_row_25_w_clkbuf_0[116]/Q[24]
+ swmatrix_row_25_w_clkbuf_0[115]/D_in PIN[14] swmatrix_row_25_w_clkbuf_0[116]/Q[1]
+ swmatrix_row_25_w_clkbuf_0[116]/Q[2] swmatrix_row_25_w_clkbuf_0[116]/D_in PHI_1_in
+ BUS[20] swmatrix_row_25_w_clkbuf_0[116]/ShiftReg_row_25_0/DFF_2phase_1$1_0[23]/gf180mcu_fd_sc_mcu9t5v0__latq_1$2_1/Q
+ BUS[23] enable_in BUS[22] BUS[25] PHI_2_in BUS[8] BUS[11] BUS[2] BUS[18] VSSd BUS[14]
+ BUS[5] swmatrix_row_25_w_clkbuf
Xswmatrix_row_25_w_clkbuf_0[117] VDDd BUS[24] BUS[21] BUS[19] BUS[17] BUS[16] BUS[15]
+ BUS[13] BUS[12] BUS[10] BUS[9] BUS[7] BUS[6] BUS[4] BUS[3] BUS[1] swmatrix_row_25_w_clkbuf_0[117]/Q[3]
+ swmatrix_row_25_w_clkbuf_0[117]/Q[4] swmatrix_row_25_w_clkbuf_0[117]/Q[5] swmatrix_row_25_w_clkbuf_0[117]/Q[6]
+ swmatrix_row_25_w_clkbuf_0[117]/Q[7] swmatrix_row_25_w_clkbuf_0[117]/Q[8] swmatrix_row_25_w_clkbuf_0[117]/Q[9]
+ swmatrix_row_25_w_clkbuf_0[117]/Q[10] swmatrix_row_25_w_clkbuf_0[117]/Q[11] swmatrix_row_25_w_clkbuf_0[117]/Q[12]
+ swmatrix_row_25_w_clkbuf_0[117]/Q[13] swmatrix_row_25_w_clkbuf_0[117]/Q[14] swmatrix_row_25_w_clkbuf_0[117]/Q[15]
+ swmatrix_row_25_w_clkbuf_0[117]/Q[16] swmatrix_row_25_w_clkbuf_0[117]/Q[17] swmatrix_row_25_w_clkbuf_0[117]/Q[18]
+ swmatrix_row_25_w_clkbuf_0[117]/Q[19] swmatrix_row_25_w_clkbuf_0[117]/Q[20] swmatrix_row_25_w_clkbuf_0[117]/Q[21]
+ swmatrix_row_25_w_clkbuf_0[117]/Q[22] swmatrix_row_25_w_clkbuf_0[117]/Q[23] swmatrix_row_25_w_clkbuf_0[117]/Q[24]
+ swmatrix_row_25_w_clkbuf_0[116]/D_in PIN[13] swmatrix_row_25_w_clkbuf_0[117]/Q[1]
+ swmatrix_row_25_w_clkbuf_0[117]/Q[2] swmatrix_row_25_w_clkbuf_0[117]/D_in PHI_1_in
+ BUS[20] swmatrix_row_25_w_clkbuf_0[117]/ShiftReg_row_25_0/DFF_2phase_1$1_0[23]/gf180mcu_fd_sc_mcu9t5v0__latq_1$2_1/Q
+ BUS[23] enable_in BUS[22] BUS[25] PHI_2_in BUS[8] BUS[11] BUS[2] BUS[18] VSSd BUS[14]
+ BUS[5] swmatrix_row_25_w_clkbuf
Xswmatrix_row_25_w_clkbuf_0[118] VDDd BUS[24] BUS[21] BUS[19] BUS[17] BUS[16] BUS[15]
+ BUS[13] BUS[12] BUS[10] BUS[9] BUS[7] BUS[6] BUS[4] BUS[3] BUS[1] swmatrix_row_25_w_clkbuf_0[118]/Q[3]
+ swmatrix_row_25_w_clkbuf_0[118]/Q[4] swmatrix_row_25_w_clkbuf_0[118]/Q[5] swmatrix_row_25_w_clkbuf_0[118]/Q[6]
+ swmatrix_row_25_w_clkbuf_0[118]/Q[7] swmatrix_row_25_w_clkbuf_0[118]/Q[8] swmatrix_row_25_w_clkbuf_0[118]/Q[9]
+ swmatrix_row_25_w_clkbuf_0[118]/Q[10] swmatrix_row_25_w_clkbuf_0[118]/Q[11] swmatrix_row_25_w_clkbuf_0[118]/Q[12]
+ swmatrix_row_25_w_clkbuf_0[118]/Q[13] swmatrix_row_25_w_clkbuf_0[118]/Q[14] swmatrix_row_25_w_clkbuf_0[118]/Q[15]
+ swmatrix_row_25_w_clkbuf_0[118]/Q[16] swmatrix_row_25_w_clkbuf_0[118]/Q[17] swmatrix_row_25_w_clkbuf_0[118]/Q[18]
+ swmatrix_row_25_w_clkbuf_0[118]/Q[19] swmatrix_row_25_w_clkbuf_0[118]/Q[20] swmatrix_row_25_w_clkbuf_0[118]/Q[21]
+ swmatrix_row_25_w_clkbuf_0[118]/Q[22] swmatrix_row_25_w_clkbuf_0[118]/Q[23] swmatrix_row_25_w_clkbuf_0[118]/Q[24]
+ swmatrix_row_25_w_clkbuf_0[117]/D_in PIN[12] swmatrix_row_25_w_clkbuf_0[118]/Q[1]
+ swmatrix_row_25_w_clkbuf_0[118]/Q[2] swmatrix_row_25_w_clkbuf_0[118]/D_in PHI_1_in
+ BUS[20] swmatrix_row_25_w_clkbuf_0[118]/ShiftReg_row_25_0/DFF_2phase_1$1_0[23]/gf180mcu_fd_sc_mcu9t5v0__latq_1$2_1/Q
+ BUS[23] enable_in BUS[22] BUS[25] PHI_2_in BUS[8] BUS[11] BUS[2] BUS[18] VSSd BUS[14]
+ BUS[5] swmatrix_row_25_w_clkbuf
Xswmatrix_row_25_w_clkbuf_0[119] VDDd BUS[24] BUS[21] BUS[19] BUS[17] BUS[16] BUS[15]
+ BUS[13] BUS[12] BUS[10] BUS[9] BUS[7] BUS[6] BUS[4] BUS[3] BUS[1] swmatrix_row_25_w_clkbuf_0[119]/Q[3]
+ swmatrix_row_25_w_clkbuf_0[119]/Q[4] swmatrix_row_25_w_clkbuf_0[119]/Q[5] swmatrix_row_25_w_clkbuf_0[119]/Q[6]
+ swmatrix_row_25_w_clkbuf_0[119]/Q[7] swmatrix_row_25_w_clkbuf_0[119]/Q[8] swmatrix_row_25_w_clkbuf_0[119]/Q[9]
+ swmatrix_row_25_w_clkbuf_0[119]/Q[10] swmatrix_row_25_w_clkbuf_0[119]/Q[11] swmatrix_row_25_w_clkbuf_0[119]/Q[12]
+ swmatrix_row_25_w_clkbuf_0[119]/Q[13] swmatrix_row_25_w_clkbuf_0[119]/Q[14] swmatrix_row_25_w_clkbuf_0[119]/Q[15]
+ swmatrix_row_25_w_clkbuf_0[119]/Q[16] swmatrix_row_25_w_clkbuf_0[119]/Q[17] swmatrix_row_25_w_clkbuf_0[119]/Q[18]
+ swmatrix_row_25_w_clkbuf_0[119]/Q[19] swmatrix_row_25_w_clkbuf_0[119]/Q[20] swmatrix_row_25_w_clkbuf_0[119]/Q[21]
+ swmatrix_row_25_w_clkbuf_0[119]/Q[22] swmatrix_row_25_w_clkbuf_0[119]/Q[23] swmatrix_row_25_w_clkbuf_0[119]/Q[24]
+ swmatrix_row_25_w_clkbuf_0[118]/D_in PIN[11] swmatrix_row_25_w_clkbuf_0[119]/Q[1]
+ swmatrix_row_25_w_clkbuf_0[119]/Q[2] swmatrix_row_25_w_clkbuf_0[119]/D_in PHI_1_in
+ BUS[20] swmatrix_row_25_w_clkbuf_0[119]/ShiftReg_row_25_0/DFF_2phase_1$1_0[23]/gf180mcu_fd_sc_mcu9t5v0__latq_1$2_1/Q
+ BUS[23] enable_in BUS[22] BUS[25] PHI_2_in BUS[8] BUS[11] BUS[2] BUS[18] VSSd BUS[14]
+ BUS[5] swmatrix_row_25_w_clkbuf
Xswmatrix_row_25_w_clkbuf_0[120] VDDd BUS[24] BUS[21] BUS[19] BUS[17] BUS[16] BUS[15]
+ BUS[13] BUS[12] BUS[10] BUS[9] BUS[7] BUS[6] BUS[4] BUS[3] BUS[1] swmatrix_row_25_w_clkbuf_0[120]/Q[3]
+ swmatrix_row_25_w_clkbuf_0[120]/Q[4] swmatrix_row_25_w_clkbuf_0[120]/Q[5] swmatrix_row_25_w_clkbuf_0[120]/Q[6]
+ swmatrix_row_25_w_clkbuf_0[120]/Q[7] swmatrix_row_25_w_clkbuf_0[120]/Q[8] swmatrix_row_25_w_clkbuf_0[120]/Q[9]
+ swmatrix_row_25_w_clkbuf_0[120]/Q[10] swmatrix_row_25_w_clkbuf_0[120]/Q[11] swmatrix_row_25_w_clkbuf_0[120]/Q[12]
+ swmatrix_row_25_w_clkbuf_0[120]/Q[13] swmatrix_row_25_w_clkbuf_0[120]/Q[14] swmatrix_row_25_w_clkbuf_0[120]/Q[15]
+ swmatrix_row_25_w_clkbuf_0[120]/Q[16] swmatrix_row_25_w_clkbuf_0[120]/Q[17] swmatrix_row_25_w_clkbuf_0[120]/Q[18]
+ swmatrix_row_25_w_clkbuf_0[120]/Q[19] swmatrix_row_25_w_clkbuf_0[120]/Q[20] swmatrix_row_25_w_clkbuf_0[120]/Q[21]
+ swmatrix_row_25_w_clkbuf_0[120]/Q[22] swmatrix_row_25_w_clkbuf_0[120]/Q[23] swmatrix_row_25_w_clkbuf_0[120]/Q[24]
+ swmatrix_row_25_w_clkbuf_0[119]/D_in PIN[10] swmatrix_row_25_w_clkbuf_0[120]/Q[1]
+ swmatrix_row_25_w_clkbuf_0[120]/Q[2] swmatrix_row_25_w_clkbuf_0[120]/D_in PHI_1_in
+ BUS[20] swmatrix_row_25_w_clkbuf_0[120]/ShiftReg_row_25_0/DFF_2phase_1$1_0[23]/gf180mcu_fd_sc_mcu9t5v0__latq_1$2_1/Q
+ BUS[23] enable_in BUS[22] BUS[25] PHI_2_in BUS[8] BUS[11] BUS[2] BUS[18] VSSd BUS[14]
+ BUS[5] swmatrix_row_25_w_clkbuf
Xswmatrix_row_25_w_clkbuf_0[121] VDDd BUS[24] BUS[21] BUS[19] BUS[17] BUS[16] BUS[15]
+ BUS[13] BUS[12] BUS[10] BUS[9] BUS[7] BUS[6] BUS[4] BUS[3] BUS[1] swmatrix_row_25_w_clkbuf_0[121]/Q[3]
+ swmatrix_row_25_w_clkbuf_0[121]/Q[4] swmatrix_row_25_w_clkbuf_0[121]/Q[5] swmatrix_row_25_w_clkbuf_0[121]/Q[6]
+ swmatrix_row_25_w_clkbuf_0[121]/Q[7] swmatrix_row_25_w_clkbuf_0[121]/Q[8] swmatrix_row_25_w_clkbuf_0[121]/Q[9]
+ swmatrix_row_25_w_clkbuf_0[121]/Q[10] swmatrix_row_25_w_clkbuf_0[121]/Q[11] swmatrix_row_25_w_clkbuf_0[121]/Q[12]
+ swmatrix_row_25_w_clkbuf_0[121]/Q[13] swmatrix_row_25_w_clkbuf_0[121]/Q[14] swmatrix_row_25_w_clkbuf_0[121]/Q[15]
+ swmatrix_row_25_w_clkbuf_0[121]/Q[16] swmatrix_row_25_w_clkbuf_0[121]/Q[17] swmatrix_row_25_w_clkbuf_0[121]/Q[18]
+ swmatrix_row_25_w_clkbuf_0[121]/Q[19] swmatrix_row_25_w_clkbuf_0[121]/Q[20] swmatrix_row_25_w_clkbuf_0[121]/Q[21]
+ swmatrix_row_25_w_clkbuf_0[121]/Q[22] swmatrix_row_25_w_clkbuf_0[121]/Q[23] swmatrix_row_25_w_clkbuf_0[121]/Q[24]
+ swmatrix_row_25_w_clkbuf_0[120]/D_in PIN[9] swmatrix_row_25_w_clkbuf_0[121]/Q[1]
+ swmatrix_row_25_w_clkbuf_0[121]/Q[2] swmatrix_row_25_w_clkbuf_0[121]/D_in PHI_1_in
+ BUS[20] swmatrix_row_25_w_clkbuf_0[121]/ShiftReg_row_25_0/DFF_2phase_1$1_0[23]/gf180mcu_fd_sc_mcu9t5v0__latq_1$2_1/Q
+ BUS[23] enable_in BUS[22] BUS[25] PHI_2_in BUS[8] BUS[11] BUS[2] BUS[18] VSSd BUS[14]
+ BUS[5] swmatrix_row_25_w_clkbuf
Xswmatrix_row_25_w_clkbuf_0[122] VDDd BUS[24] BUS[21] BUS[19] BUS[17] BUS[16] BUS[15]
+ BUS[13] BUS[12] BUS[10] BUS[9] BUS[7] BUS[6] BUS[4] BUS[3] BUS[1] swmatrix_row_25_w_clkbuf_0[122]/Q[3]
+ swmatrix_row_25_w_clkbuf_0[122]/Q[4] swmatrix_row_25_w_clkbuf_0[122]/Q[5] swmatrix_row_25_w_clkbuf_0[122]/Q[6]
+ swmatrix_row_25_w_clkbuf_0[122]/Q[7] swmatrix_row_25_w_clkbuf_0[122]/Q[8] swmatrix_row_25_w_clkbuf_0[122]/Q[9]
+ swmatrix_row_25_w_clkbuf_0[122]/Q[10] swmatrix_row_25_w_clkbuf_0[122]/Q[11] swmatrix_row_25_w_clkbuf_0[122]/Q[12]
+ swmatrix_row_25_w_clkbuf_0[122]/Q[13] swmatrix_row_25_w_clkbuf_0[122]/Q[14] swmatrix_row_25_w_clkbuf_0[122]/Q[15]
+ swmatrix_row_25_w_clkbuf_0[122]/Q[16] swmatrix_row_25_w_clkbuf_0[122]/Q[17] swmatrix_row_25_w_clkbuf_0[122]/Q[18]
+ swmatrix_row_25_w_clkbuf_0[122]/Q[19] swmatrix_row_25_w_clkbuf_0[122]/Q[20] swmatrix_row_25_w_clkbuf_0[122]/Q[21]
+ swmatrix_row_25_w_clkbuf_0[122]/Q[22] swmatrix_row_25_w_clkbuf_0[122]/Q[23] swmatrix_row_25_w_clkbuf_0[122]/Q[24]
+ swmatrix_row_25_w_clkbuf_0[121]/D_in PIN[8] swmatrix_row_25_w_clkbuf_0[122]/Q[1]
+ swmatrix_row_25_w_clkbuf_0[122]/Q[2] swmatrix_row_25_w_clkbuf_0[122]/D_in PHI_1_in
+ BUS[20] swmatrix_row_25_w_clkbuf_0[122]/ShiftReg_row_25_0/DFF_2phase_1$1_0[23]/gf180mcu_fd_sc_mcu9t5v0__latq_1$2_1/Q
+ BUS[23] enable_in BUS[22] BUS[25] PHI_2_in BUS[8] BUS[11] BUS[2] BUS[18] VSSd BUS[14]
+ BUS[5] swmatrix_row_25_w_clkbuf
Xswmatrix_row_25_w_clkbuf_0[123] VDDd BUS[24] BUS[21] BUS[19] BUS[17] BUS[16] BUS[15]
+ BUS[13] BUS[12] BUS[10] BUS[9] BUS[7] BUS[6] BUS[4] BUS[3] BUS[1] swmatrix_row_25_w_clkbuf_0[123]/Q[3]
+ swmatrix_row_25_w_clkbuf_0[123]/Q[4] swmatrix_row_25_w_clkbuf_0[123]/Q[5] swmatrix_row_25_w_clkbuf_0[123]/Q[6]
+ swmatrix_row_25_w_clkbuf_0[123]/Q[7] swmatrix_row_25_w_clkbuf_0[123]/Q[8] swmatrix_row_25_w_clkbuf_0[123]/Q[9]
+ swmatrix_row_25_w_clkbuf_0[123]/Q[10] swmatrix_row_25_w_clkbuf_0[123]/Q[11] swmatrix_row_25_w_clkbuf_0[123]/Q[12]
+ swmatrix_row_25_w_clkbuf_0[123]/Q[13] swmatrix_row_25_w_clkbuf_0[123]/Q[14] swmatrix_row_25_w_clkbuf_0[123]/Q[15]
+ swmatrix_row_25_w_clkbuf_0[123]/Q[16] swmatrix_row_25_w_clkbuf_0[123]/Q[17] swmatrix_row_25_w_clkbuf_0[123]/Q[18]
+ swmatrix_row_25_w_clkbuf_0[123]/Q[19] swmatrix_row_25_w_clkbuf_0[123]/Q[20] swmatrix_row_25_w_clkbuf_0[123]/Q[21]
+ swmatrix_row_25_w_clkbuf_0[123]/Q[22] swmatrix_row_25_w_clkbuf_0[123]/Q[23] swmatrix_row_25_w_clkbuf_0[123]/Q[24]
+ swmatrix_row_25_w_clkbuf_0[122]/D_in PIN[7] swmatrix_row_25_w_clkbuf_0[123]/Q[1]
+ swmatrix_row_25_w_clkbuf_0[123]/Q[2] swmatrix_row_25_w_clkbuf_0[123]/D_in PHI_1_in
+ BUS[20] swmatrix_row_25_w_clkbuf_0[123]/ShiftReg_row_25_0/DFF_2phase_1$1_0[23]/gf180mcu_fd_sc_mcu9t5v0__latq_1$2_1/Q
+ BUS[23] enable_in BUS[22] BUS[25] PHI_2_in BUS[8] BUS[11] BUS[2] BUS[18] VSSd BUS[14]
+ BUS[5] swmatrix_row_25_w_clkbuf
Xswmatrix_row_25_w_clkbuf_0[124] VDDd BUS[24] BUS[21] BUS[19] BUS[17] BUS[16] BUS[15]
+ BUS[13] BUS[12] BUS[10] BUS[9] BUS[7] BUS[6] BUS[4] BUS[3] BUS[1] swmatrix_row_25_w_clkbuf_0[124]/Q[3]
+ swmatrix_row_25_w_clkbuf_0[124]/Q[4] swmatrix_row_25_w_clkbuf_0[124]/Q[5] swmatrix_row_25_w_clkbuf_0[124]/Q[6]
+ swmatrix_row_25_w_clkbuf_0[124]/Q[7] swmatrix_row_25_w_clkbuf_0[124]/Q[8] swmatrix_row_25_w_clkbuf_0[124]/Q[9]
+ swmatrix_row_25_w_clkbuf_0[124]/Q[10] swmatrix_row_25_w_clkbuf_0[124]/Q[11] swmatrix_row_25_w_clkbuf_0[124]/Q[12]
+ swmatrix_row_25_w_clkbuf_0[124]/Q[13] swmatrix_row_25_w_clkbuf_0[124]/Q[14] swmatrix_row_25_w_clkbuf_0[124]/Q[15]
+ swmatrix_row_25_w_clkbuf_0[124]/Q[16] swmatrix_row_25_w_clkbuf_0[124]/Q[17] swmatrix_row_25_w_clkbuf_0[124]/Q[18]
+ swmatrix_row_25_w_clkbuf_0[124]/Q[19] swmatrix_row_25_w_clkbuf_0[124]/Q[20] swmatrix_row_25_w_clkbuf_0[124]/Q[21]
+ swmatrix_row_25_w_clkbuf_0[124]/Q[22] swmatrix_row_25_w_clkbuf_0[124]/Q[23] swmatrix_row_25_w_clkbuf_0[124]/Q[24]
+ swmatrix_row_25_w_clkbuf_0[123]/D_in PIN[6] swmatrix_row_25_w_clkbuf_0[124]/Q[1]
+ swmatrix_row_25_w_clkbuf_0[124]/Q[2] swmatrix_row_25_w_clkbuf_0[124]/D_in PHI_1_in
+ BUS[20] swmatrix_row_25_w_clkbuf_0[124]/ShiftReg_row_25_0/DFF_2phase_1$1_0[23]/gf180mcu_fd_sc_mcu9t5v0__latq_1$2_1/Q
+ BUS[23] enable_in BUS[22] BUS[25] PHI_2_in BUS[8] BUS[11] BUS[2] BUS[18] VSSd BUS[14]
+ BUS[5] swmatrix_row_25_w_clkbuf
Xswmatrix_row_25_w_clkbuf_0[125] VDDd BUS[24] BUS[21] BUS[19] BUS[17] BUS[16] BUS[15]
+ BUS[13] BUS[12] BUS[10] BUS[9] BUS[7] BUS[6] BUS[4] BUS[3] BUS[1] swmatrix_row_25_w_clkbuf_0[125]/Q[3]
+ swmatrix_row_25_w_clkbuf_0[125]/Q[4] swmatrix_row_25_w_clkbuf_0[125]/Q[5] swmatrix_row_25_w_clkbuf_0[125]/Q[6]
+ swmatrix_row_25_w_clkbuf_0[125]/Q[7] swmatrix_row_25_w_clkbuf_0[125]/Q[8] swmatrix_row_25_w_clkbuf_0[125]/Q[9]
+ swmatrix_row_25_w_clkbuf_0[125]/Q[10] swmatrix_row_25_w_clkbuf_0[125]/Q[11] swmatrix_row_25_w_clkbuf_0[125]/Q[12]
+ swmatrix_row_25_w_clkbuf_0[125]/Q[13] swmatrix_row_25_w_clkbuf_0[125]/Q[14] swmatrix_row_25_w_clkbuf_0[125]/Q[15]
+ swmatrix_row_25_w_clkbuf_0[125]/Q[16] swmatrix_row_25_w_clkbuf_0[125]/Q[17] swmatrix_row_25_w_clkbuf_0[125]/Q[18]
+ swmatrix_row_25_w_clkbuf_0[125]/Q[19] swmatrix_row_25_w_clkbuf_0[125]/Q[20] swmatrix_row_25_w_clkbuf_0[125]/Q[21]
+ swmatrix_row_25_w_clkbuf_0[125]/Q[22] swmatrix_row_25_w_clkbuf_0[125]/Q[23] swmatrix_row_25_w_clkbuf_0[125]/Q[24]
+ swmatrix_row_25_w_clkbuf_0[124]/D_in PIN[5] swmatrix_row_25_w_clkbuf_0[125]/Q[1]
+ swmatrix_row_25_w_clkbuf_0[125]/Q[2] swmatrix_row_25_w_clkbuf_0[125]/D_in PHI_1_in
+ BUS[20] swmatrix_row_25_w_clkbuf_0[125]/ShiftReg_row_25_0/DFF_2phase_1$1_0[23]/gf180mcu_fd_sc_mcu9t5v0__latq_1$2_1/Q
+ BUS[23] enable_in BUS[22] BUS[25] PHI_2_in BUS[8] BUS[11] BUS[2] BUS[18] VSSd BUS[14]
+ BUS[5] swmatrix_row_25_w_clkbuf
Xswmatrix_row_25_w_clkbuf_0[126] VDDd BUS[24] BUS[21] BUS[19] BUS[17] BUS[16] BUS[15]
+ BUS[13] BUS[12] BUS[10] BUS[9] BUS[7] BUS[6] BUS[4] BUS[3] BUS[1] swmatrix_row_25_w_clkbuf_0[126]/Q[3]
+ swmatrix_row_25_w_clkbuf_0[126]/Q[4] swmatrix_row_25_w_clkbuf_0[126]/Q[5] swmatrix_row_25_w_clkbuf_0[126]/Q[6]
+ swmatrix_row_25_w_clkbuf_0[126]/Q[7] swmatrix_row_25_w_clkbuf_0[126]/Q[8] swmatrix_row_25_w_clkbuf_0[126]/Q[9]
+ swmatrix_row_25_w_clkbuf_0[126]/Q[10] swmatrix_row_25_w_clkbuf_0[126]/Q[11] swmatrix_row_25_w_clkbuf_0[126]/Q[12]
+ swmatrix_row_25_w_clkbuf_0[126]/Q[13] swmatrix_row_25_w_clkbuf_0[126]/Q[14] swmatrix_row_25_w_clkbuf_0[126]/Q[15]
+ swmatrix_row_25_w_clkbuf_0[126]/Q[16] swmatrix_row_25_w_clkbuf_0[126]/Q[17] swmatrix_row_25_w_clkbuf_0[126]/Q[18]
+ swmatrix_row_25_w_clkbuf_0[126]/Q[19] swmatrix_row_25_w_clkbuf_0[126]/Q[20] swmatrix_row_25_w_clkbuf_0[126]/Q[21]
+ swmatrix_row_25_w_clkbuf_0[126]/Q[22] swmatrix_row_25_w_clkbuf_0[126]/Q[23] swmatrix_row_25_w_clkbuf_0[126]/Q[24]
+ swmatrix_row_25_w_clkbuf_0[125]/D_in PIN[4] swmatrix_row_25_w_clkbuf_0[126]/Q[1]
+ swmatrix_row_25_w_clkbuf_0[126]/Q[2] swmatrix_row_25_w_clkbuf_0[126]/D_in PHI_1_in
+ BUS[20] swmatrix_row_25_w_clkbuf_0[126]/ShiftReg_row_25_0/DFF_2phase_1$1_0[23]/gf180mcu_fd_sc_mcu9t5v0__latq_1$2_1/Q
+ BUS[23] enable_in BUS[22] BUS[25] PHI_2_in BUS[8] BUS[11] BUS[2] BUS[18] VSSd BUS[14]
+ BUS[5] swmatrix_row_25_w_clkbuf
Xswmatrix_row_25_w_clkbuf_0[127] VDDd BUS[24] BUS[21] BUS[19] BUS[17] BUS[16] BUS[15]
+ BUS[13] BUS[12] BUS[10] BUS[9] BUS[7] BUS[6] BUS[4] BUS[3] BUS[1] swmatrix_row_25_w_clkbuf_0[127]/Q[3]
+ swmatrix_row_25_w_clkbuf_0[127]/Q[4] swmatrix_row_25_w_clkbuf_0[127]/Q[5] swmatrix_row_25_w_clkbuf_0[127]/Q[6]
+ swmatrix_row_25_w_clkbuf_0[127]/Q[7] swmatrix_row_25_w_clkbuf_0[127]/Q[8] swmatrix_row_25_w_clkbuf_0[127]/Q[9]
+ swmatrix_row_25_w_clkbuf_0[127]/Q[10] swmatrix_row_25_w_clkbuf_0[127]/Q[11] swmatrix_row_25_w_clkbuf_0[127]/Q[12]
+ swmatrix_row_25_w_clkbuf_0[127]/Q[13] swmatrix_row_25_w_clkbuf_0[127]/Q[14] swmatrix_row_25_w_clkbuf_0[127]/Q[15]
+ swmatrix_row_25_w_clkbuf_0[127]/Q[16] swmatrix_row_25_w_clkbuf_0[127]/Q[17] swmatrix_row_25_w_clkbuf_0[127]/Q[18]
+ swmatrix_row_25_w_clkbuf_0[127]/Q[19] swmatrix_row_25_w_clkbuf_0[127]/Q[20] swmatrix_row_25_w_clkbuf_0[127]/Q[21]
+ swmatrix_row_25_w_clkbuf_0[127]/Q[22] swmatrix_row_25_w_clkbuf_0[127]/Q[23] swmatrix_row_25_w_clkbuf_0[127]/Q[24]
+ swmatrix_row_25_w_clkbuf_0[126]/D_in PIN[3] swmatrix_row_25_w_clkbuf_0[127]/Q[1]
+ swmatrix_row_25_w_clkbuf_0[127]/Q[2] swmatrix_row_25_w_clkbuf_0[127]/D_in PHI_1_in
+ BUS[20] swmatrix_row_25_w_clkbuf_0[127]/ShiftReg_row_25_0/DFF_2phase_1$1_0[23]/gf180mcu_fd_sc_mcu9t5v0__latq_1$2_1/Q
+ BUS[23] enable_in BUS[22] BUS[25] PHI_2_in BUS[8] BUS[11] BUS[2] BUS[18] VSSd BUS[14]
+ BUS[5] swmatrix_row_25_w_clkbuf
Xswmatrix_row_25_w_clkbuf_0[128] VDDd BUS[24] BUS[21] BUS[19] BUS[17] BUS[16] BUS[15]
+ BUS[13] BUS[12] BUS[10] BUS[9] BUS[7] BUS[6] BUS[4] BUS[3] BUS[1] swmatrix_row_25_w_clkbuf_0[128]/Q[3]
+ swmatrix_row_25_w_clkbuf_0[128]/Q[4] swmatrix_row_25_w_clkbuf_0[128]/Q[5] swmatrix_row_25_w_clkbuf_0[128]/Q[6]
+ swmatrix_row_25_w_clkbuf_0[128]/Q[7] swmatrix_row_25_w_clkbuf_0[128]/Q[8] swmatrix_row_25_w_clkbuf_0[128]/Q[9]
+ swmatrix_row_25_w_clkbuf_0[128]/Q[10] swmatrix_row_25_w_clkbuf_0[128]/Q[11] swmatrix_row_25_w_clkbuf_0[128]/Q[12]
+ swmatrix_row_25_w_clkbuf_0[128]/Q[13] swmatrix_row_25_w_clkbuf_0[128]/Q[14] swmatrix_row_25_w_clkbuf_0[128]/Q[15]
+ swmatrix_row_25_w_clkbuf_0[128]/Q[16] swmatrix_row_25_w_clkbuf_0[128]/Q[17] swmatrix_row_25_w_clkbuf_0[128]/Q[18]
+ swmatrix_row_25_w_clkbuf_0[128]/Q[19] swmatrix_row_25_w_clkbuf_0[128]/Q[20] swmatrix_row_25_w_clkbuf_0[128]/Q[21]
+ swmatrix_row_25_w_clkbuf_0[128]/Q[22] swmatrix_row_25_w_clkbuf_0[128]/Q[23] swmatrix_row_25_w_clkbuf_0[128]/Q[24]
+ swmatrix_row_25_w_clkbuf_0[127]/D_in PIN[2] swmatrix_row_25_w_clkbuf_0[128]/Q[1]
+ swmatrix_row_25_w_clkbuf_0[128]/Q[2] swmatrix_row_25_w_clkbuf_0[128]/D_in PHI_1_in
+ BUS[20] swmatrix_row_25_w_clkbuf_0[128]/ShiftReg_row_25_0/DFF_2phase_1$1_0[23]/gf180mcu_fd_sc_mcu9t5v0__latq_1$2_1/Q
+ BUS[23] enable_in BUS[22] BUS[25] PHI_2_in BUS[8] BUS[11] BUS[2] BUS[18] VSSd BUS[14]
+ BUS[5] swmatrix_row_25_w_clkbuf
Xswmatrix_row_25_w_clkbuf_0[129] VDDd BUS[24] BUS[21] BUS[19] BUS[17] BUS[16] BUS[15]
+ BUS[13] BUS[12] BUS[10] BUS[9] BUS[7] BUS[6] BUS[4] BUS[3] BUS[1] swmatrix_row_25_w_clkbuf_0[129]/Q[3]
+ swmatrix_row_25_w_clkbuf_0[129]/Q[4] swmatrix_row_25_w_clkbuf_0[129]/Q[5] swmatrix_row_25_w_clkbuf_0[129]/Q[6]
+ swmatrix_row_25_w_clkbuf_0[129]/Q[7] swmatrix_row_25_w_clkbuf_0[129]/Q[8] swmatrix_row_25_w_clkbuf_0[129]/Q[9]
+ swmatrix_row_25_w_clkbuf_0[129]/Q[10] swmatrix_row_25_w_clkbuf_0[129]/Q[11] swmatrix_row_25_w_clkbuf_0[129]/Q[12]
+ swmatrix_row_25_w_clkbuf_0[129]/Q[13] swmatrix_row_25_w_clkbuf_0[129]/Q[14] swmatrix_row_25_w_clkbuf_0[129]/Q[15]
+ swmatrix_row_25_w_clkbuf_0[129]/Q[16] swmatrix_row_25_w_clkbuf_0[129]/Q[17] swmatrix_row_25_w_clkbuf_0[129]/Q[18]
+ swmatrix_row_25_w_clkbuf_0[129]/Q[19] swmatrix_row_25_w_clkbuf_0[129]/Q[20] swmatrix_row_25_w_clkbuf_0[129]/Q[21]
+ swmatrix_row_25_w_clkbuf_0[129]/Q[22] swmatrix_row_25_w_clkbuf_0[129]/Q[23] swmatrix_row_25_w_clkbuf_0[129]/Q[24]
+ swmatrix_row_25_w_clkbuf_0[128]/D_in PIN[1] swmatrix_row_25_w_clkbuf_0[129]/Q[1]
+ swmatrix_row_25_w_clkbuf_0[129]/Q[2] data_in PHI_1_in BUS[20] swmatrix_row_25_w_clkbuf_0[129]/ShiftReg_row_25_0/DFF_2phase_1$1_0[23]/gf180mcu_fd_sc_mcu9t5v0__latq_1$2_1/Q
+ BUS[23] enable_in BUS[22] BUS[25] PHI_2_in BUS[8] BUS[11] BUS[2] BUS[18] VSSd BUS[14]
+ BUS[5] swmatrix_row_25_w_clkbuf
.ends
