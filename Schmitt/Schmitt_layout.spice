* NGSPICE file created from Schmitt.ext - technology: gf180mcuD

.subckt nfet a_306_n60# a_202_0# a_n84_0# a_62_n60# a_446_0# VSUBS
X0 a_202_0# a_62_n60# a_n84_0# VSUBS nfet_05v0 ad=0.26p pd=1.52u as=0.73p ps=3.46u w=1u l=0.7u
X1 a_446_0# a_306_n60# a_202_0# VSUBS nfet_05v0 ad=0.73p pd=3.46u as=0.26p ps=1.52u w=1u l=0.7u
.ends

.subckt pfet$1 a_172_0# a_62_n136# a_n92_0# a_276_n136# a_386_0# w_n214_n122#
X0 a_386_0# a_276_n136# a_172_0# w_n214_n122# pfet_05v0 ad=2.31p pd=7.54u as=0.78p ps=3.52u w=3u l=0.55u
X1 a_172_0# a_62_n136# a_n92_0# w_n214_n122# pfet_05v0 ad=0.78p pd=3.52u as=2.31p ps=7.54u w=3u l=0.55u
.ends

.subckt Schmitt VDD VSS Vin Vo
Xnfet_0 m1_949_n51# VSS Vo m1_949_n51# Vo VSS nfet
Xnfet_2 Vin m1_949_n51# m1_n189_n51# Vin m1_n189_n51# VSS nfet
Xnfet_1 m1_949_n51# VDD m1_n189_n51# m1_949_n51# m1_n189_n51# VSS nfet
Xnfet_3 Vin VSS m1_n189_n51# Vin m1_n189_n51# VSS nfet
Xpfet$1_0 VSS m1_949_n51# m1_n176_1108# m1_949_n51# m1_n176_1108# VDD pfet$1
Xpfet$1_1 VDD m1_949_n51# Vo m1_949_n51# Vo VDD pfet$1
Xpfet$1_3 m1_949_n51# Vin m1_n176_1108# Vin m1_n176_1108# VDD pfet$1
Xpfet$1_2 VDD Vin m1_n176_1108# Vin m1_n176_1108# VDD pfet$1
.ends
