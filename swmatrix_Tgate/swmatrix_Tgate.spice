** sch_path: /foss/designs/libs/switch_matrix_gf180mcu_9t5v0/swmatrix_Tgate/swmatrix_Tgate.sch

./include /foss/pdks/gf180mcuD/libs.ref/gf180mcu_fd_sc_mcu9t5v0/spice/gf180mcu_fd_sc_mcu9t5v0.spice

.subckt swmatrix_Tgate control T2 T1 VDDd VSSd enable
*.PININFO T1:B T2:B VDDd:B VSSd:B control:I enable:I
XM1 T1 gated_control T2 VSSd nfet_03v3 L=0.28u W=48u nf=6 m=1
XM2 T1 gated_controlb T2 VDDd pfet_03v3 L=0.28u W=144u nf=18 m=1
x1 gated_control gated_controlb VDDd VDDd VSSd VSSd gf180mcu_fd_sc_mcu9t5v0__inv_1
x2 control enable net1 VDDd VDDd VSSd VSSd gf180mcu_fd_sc_mcu9t5v0__nand2_1
x3 net1 gated_control VDDd VDDd VSSd VSSd gf180mcu_fd_sc_mcu9t5v0__inv_1
**** begin user architecture code

.param mn_w=48u
.param mp_w=144u

**** end user architecture code
.ends
